// Generated for: spectre
// Generated on: May 14 15:53:24 2024
// Design library name: projeto
// Design cell name: 8x8_benes_tb
// Design view name: config
simulator lang=spectre
global 0 vdd!
include "/home/cadmgr/libs/gpdk045/v6.0/gpdk045/../models/spectre/gpdk045.scs" section=mc

parameters Supply=1

// Inherited view list: spectre schematic cmos_sch veriloga
// Library name: projeto
// Cell name: 8x8_benes
// View name: av_extracted
// View type: maskLayout
subckt projeto_8x8_benes_av_extracted S00 S01 S02 S03 S04 S10 S11 S12 S13 \
        S14 S20 S21 S22 S23 S24 S30 S31 S32 S33 S34 X0 X1 X2 X3 X4 X5 X6 \
        X7 Y0 Y1 Y2 Y3 Y4 Y5 Y6 Y7
    I0\|PM19 (\4\:net2 \4\:I0\|N_S10 I0\|net6 vdd!) g45p1svt w=(1.2e-07) \
        l=4.5e-08 nf=1 as=2.52e-14 ad=1.92e-14 ps=6.6e-07 pd=5.6e-07 \
        nrd=1.16667 nrs=1.16667 sa=2.1e-07 sb=7.55e-07 sd=160n sca=41.6117 \
        scb=0.0399934 scc=0.00517383 m=(1)
    I0\|PM2 (\4\:net4 \4\:I0\|N_S00 I0\|net10 vdd!) g45p1svt w=(1.2e-07) \
        l=4.5e-08 nf=1 as=2.52e-14 ad=1.92e-14 ps=6.6e-07 pd=5.6e-07 \
        nrd=1.16667 nrs=1.16667 sa=2.1e-07 sb=7.55e-07 sd=160n sca=41.6117 \
        scb=0.0399934 scc=0.00517383 m=(1)
    I0\|PM29 (\4\:net2 \1\:S11 I0\|net5 vdd!) g45p1svt w=(1.2e-07) \
        l=4.5e-08 nf=1 as=1.92e-14 ad=1.92e-14 ps=5.6e-07 pd=5.6e-07 \
        nrd=1.16667 nrs=1.16667 sa=4.15e-07 sb=5.5e-07 sd=160n sca=41.6117 \
        scb=0.0399934 scc=0.00517383 m=(1)
    I0\|PM0 (\4\:net4 \1\:S01 I0\|net9 vdd!) g45p1svt w=(1.2e-07) \
        l=4.5e-08 nf=1 as=1.92e-14 ad=1.92e-14 ps=5.6e-07 pd=5.6e-07 \
        nrd=1.16667 nrs=1.16667 sa=4.15e-07 sb=5.5e-07 sd=160n sca=41.6117 \
        scb=0.0399934 scc=0.00517383 m=(1)
    I0\|PM17 (I0\|net5 I0\|N_S10 \4\:net1 vdd!) g45p1svt w=(1.2e-07) \
        l=4.5e-08 nf=1 as=1.92e-14 ad=1.92e-14 ps=5.6e-07 pd=5.6e-07 \
        nrd=1.16667 nrs=1.16667 sa=6.2e-07 sb=3.45e-07 sd=160n sca=41.6117 \
        scb=0.0399934 scc=0.00517383 m=(1)
    I0\|PM1 (I0\|net9 I0\|N_S00 \6\:net3 vdd!) g45p1svt w=(1.2e-07) \
        l=4.5e-08 nf=1 as=1.92e-14 ad=1.92e-14 ps=5.6e-07 pd=5.6e-07 \
        nrd=1.16667 nrs=1.16667 sa=6.2e-07 sb=3.45e-07 sd=160n sca=41.6117 \
        scb=0.0399934 scc=0.00517383 m=(1)
    I0\|PM15 (\4\:net1 \2\:S11 \5\:I0\|net6 vdd!) g45p1svt w=(1.2e-07) \
        l=4.5e-08 nf=1 as=1.68e-14 ad=1.92e-14 ps=5.2e-07 pd=5.6e-07 \
        nrd=1.16667 nrs=1.16667 sa=8.25e-07 sb=1.4e-07 sd=160n sca=41.6117 \
        scb=0.0399934 scc=0.00517383 m=(1)
    I0\|PM3 (\6\:net3 \2\:S01 \5\:I0\|net10 vdd!) g45p1svt w=(1.2e-07) \
        l=4.5e-08 nf=1 as=1.68e-14 ad=1.92e-14 ps=5.2e-07 pd=5.6e-07 \
        nrd=1.16667 nrs=1.16667 sa=8.25e-07 sb=1.4e-07 sd=160n sca=41.6117 \
        scb=0.0399934 scc=0.00517383 m=(1)
    I0\|PM22 (\11\:I0\|net10 \4\:I0\|N_S11 I0\|net8 vdd!) g45p1svt \
        w=(1.2e-07) l=4.5e-08 nf=1 as=2.52e-14 ad=1.92e-14 ps=6.6e-07 \
        pd=5.6e-07 nrd=1.16667 nrs=1.16667 sa=2.1e-07 sb=7.55e-07 sd=160n \
        sca=41.6117 scb=0.0399934 scc=0.00517383 m=(1)
    I0\|PM8 (\9\:I0\|net9 \4\:I0\|N_S01 I0\|net3 vdd!) g45p1svt \
        w=(1.2e-07) l=4.5e-08 nf=1 as=2.52e-14 ad=1.92e-14 ps=6.6e-07 \
        pd=5.6e-07 nrd=1.16667 nrs=1.16667 sa=2.1e-07 sb=7.55e-07 sd=160n \
        sca=41.6117 scb=0.0399934 scc=0.00517383 m=(1)
    I0\|PM23 (\11\:I0\|net10 \1\:S12 I0\|net2 vdd!) g45p1svt w=(1.2e-07) \
        l=4.5e-08 nf=1 as=1.92e-14 ad=1.92e-14 ps=5.6e-07 pd=5.6e-07 \
        nrd=1.16667 nrs=1.16667 sa=4.15e-07 sb=5.5e-07 sd=160n sca=41.6117 \
        scb=0.0399934 scc=0.00517383 m=(1)
    I0\|PM9 (\9\:I0\|net9 \1\:S02 I0\|net1 vdd!) g45p1svt w=(1.2e-07) \
        l=4.5e-08 nf=1 as=1.92e-14 ad=1.92e-14 ps=5.6e-07 pd=5.6e-07 \
        nrd=1.16667 nrs=1.16667 sa=4.15e-07 sb=5.5e-07 sd=160n sca=41.6117 \
        scb=0.0399934 scc=0.00517383 m=(1)
    I0\|PM20 (I0\|net2 I0\|N_S11 \7\:I0\|net6 vdd!) g45p1svt w=(1.2e-07) \
        l=4.5e-08 nf=1 as=1.92e-14 ad=1.92e-14 ps=5.6e-07 pd=5.6e-07 \
        nrd=1.16667 nrs=1.16667 sa=6.2e-07 sb=3.45e-07 sd=160n sca=41.6117 \
        scb=0.0399934 scc=0.00517383 m=(1)
    I0\|PM6 (I0\|net1 I0\|N_S01 \5\:I0\|net5 vdd!) g45p1svt w=(1.2e-07) \
        l=4.5e-08 nf=1 as=1.92e-14 ad=1.92e-14 ps=5.6e-07 pd=5.6e-07 \
        nrd=1.16667 nrs=1.16667 sa=6.2e-07 sb=3.45e-07 sd=160n sca=41.6117 \
        scb=0.0399934 scc=0.00517383 m=(1)
    I0\|PM16 (\7\:I0\|net6 \2\:S12 \5\:I0\|net8 vdd!) g45p1svt w=(1.2e-07) \
        l=4.5e-08 nf=1 as=1.68e-14 ad=1.92e-14 ps=5.2e-07 pd=5.6e-07 \
        nrd=1.16667 nrs=1.16667 sa=8.25e-07 sb=1.4e-07 sd=160n sca=41.6117 \
        scb=0.0399934 scc=0.00517383 m=(1)
    I0\|PM5 (\5\:I0\|net5 \2\:S02 \5\:I0\|net3 vdd!) g45p1svt w=(1.2e-07) \
        l=4.5e-08 nf=1 as=1.68e-14 ad=1.92e-14 ps=5.2e-07 pd=5.6e-07 \
        nrd=1.16667 nrs=1.16667 sa=8.25e-07 sb=1.4e-07 sd=160n sca=41.6117 \
        scb=0.0399934 scc=0.00517383 m=(1)
    I0\|PM27 (\11\:I0\|net3 \4\:I0\|N_S12 net5 vdd!) g45p1svt w=(1.2e-07) \
        l=4.5e-08 nf=1 as=2.52e-14 ad=1.92e-14 ps=6.6e-07 pd=5.6e-07 \
        nrd=1.16667 nrs=1.16667 sa=2.1e-07 sb=7.55e-07 sd=160n sca=41.6117 \
        scb=0.0399934 scc=0.00517383 m=(1)
    I0\|PM13 (\9\:I0\|net1 \4\:I0\|N_S02 \3\:net7 vdd!) g45p1svt \
        w=(1.2e-07) l=4.5e-08 nf=1 as=2.52e-14 ad=1.92e-14 ps=6.6e-07 \
        pd=5.6e-07 nrd=1.16667 nrs=1.16667 sa=2.1e-07 sb=7.55e-07 sd=160n \
        sca=41.6117 scb=0.0399934 scc=0.00517383 m=(1)
    I0\|PM28 (\11\:I0\|net3 \1\:S13 \6\:net6 vdd!) g45p1svt w=(1.2e-07) \
        l=4.5e-08 nf=1 as=1.92e-14 ad=1.92e-14 ps=5.6e-07 pd=5.6e-07 \
        nrd=1.16667 nrs=1.16667 sa=4.15e-07 sb=5.5e-07 sd=160n sca=41.6117 \
        scb=0.0399934 scc=0.00517383 m=(1)
    I0\|PM14 (\9\:I0\|net1 \1\:S03 \6\:net8 vdd!) g45p1svt w=(1.2e-07) \
        l=4.5e-08 nf=1 as=1.92e-14 ad=1.92e-14 ps=5.6e-07 pd=5.6e-07 \
        nrd=1.16667 nrs=1.16667 sa=4.15e-07 sb=5.5e-07 sd=160n sca=41.6117 \
        scb=0.0399934 scc=0.00517383 m=(1)
    I0\|PM25 (\6\:net6 I0\|N_S12 \7\:I0\|net8 vdd!) g45p1svt w=(1.2e-07) \
        l=4.5e-08 nf=1 as=1.92e-14 ad=1.92e-14 ps=5.6e-07 pd=5.6e-07 \
        nrd=1.16667 nrs=1.16667 sa=6.2e-07 sb=3.45e-07 sd=160n sca=41.6117 \
        scb=0.0399934 scc=0.00517383 m=(1)
    I0\|PM11 (\6\:net8 I0\|N_S02 \5\:I0\|net2 vdd!) g45p1svt w=(1.2e-07) \
        l=4.5e-08 nf=1 as=1.92e-14 ad=1.92e-14 ps=5.6e-07 pd=5.6e-07 \
        nrd=1.16667 nrs=1.16667 sa=6.2e-07 sb=3.45e-07 sd=160n sca=41.6117 \
        scb=0.0399934 scc=0.00517383 m=(1)
    I0\|PM24 (\7\:I0\|net8 \2\:S13 \5\:net5 vdd!) g45p1svt w=(1.2e-07) \
        l=4.5e-08 nf=1 as=1.68e-14 ad=1.92e-14 ps=5.2e-07 pd=5.6e-07 \
        nrd=1.16667 nrs=1.16667 sa=8.25e-07 sb=1.4e-07 sd=160n sca=41.6117 \
        scb=0.0399934 scc=0.00517383 m=(1)
    I0\|PM10 (\5\:I0\|net2 \2\:S03 \5\:net7 vdd!) g45p1svt w=(1.2e-07) \
        l=4.5e-08 nf=1 as=1.68e-14 ad=1.92e-14 ps=5.2e-07 pd=5.6e-07 \
        nrd=1.16667 nrs=1.16667 sa=8.25e-07 sb=1.4e-07 sd=160n sca=41.6117 \
        scb=0.0399934 scc=0.00517383 m=(1)
    I1\|PM19 (\10\:net16 \4\:I1\|N_S10 I1\|net6 vdd!) g45p1svt w=(1.2e-07) \
        l=4.5e-08 nf=1 as=2.52e-14 ad=1.92e-14 ps=6.6e-07 pd=5.6e-07 \
        nrd=1.16667 nrs=1.16667 sa=2.1e-07 sb=7.55e-07 sd=160n sca=41.6117 \
        scb=0.0399934 scc=0.00517383 m=(1)
    I1\|PM2 (\10\:net18 \4\:I1\|N_S00 I1\|net10 vdd!) g45p1svt w=(1.2e-07) \
        l=4.5e-08 nf=1 as=2.52e-14 ad=1.92e-14 ps=6.6e-07 pd=5.6e-07 \
        nrd=1.16667 nrs=1.16667 sa=2.1e-07 sb=7.55e-07 sd=160n sca=41.6117 \
        scb=0.0399934 scc=0.00517383 m=(1)
    I1\|PM29 (\10\:net16 \1\:S31 I1\|net5 vdd!) g45p1svt w=(1.2e-07) \
        l=4.5e-08 nf=1 as=1.92e-14 ad=1.92e-14 ps=5.6e-07 pd=5.6e-07 \
        nrd=1.16667 nrs=1.16667 sa=4.15e-07 sb=5.5e-07 sd=160n sca=41.6117 \
        scb=0.0399934 scc=0.00517383 m=(1)
    I1\|PM0 (\10\:net18 \1\:S21 I1\|net9 vdd!) g45p1svt w=(1.2e-07) \
        l=4.5e-08 nf=1 as=1.92e-14 ad=1.92e-14 ps=5.6e-07 pd=5.6e-07 \
        nrd=1.16667 nrs=1.16667 sa=4.15e-07 sb=5.5e-07 sd=160n sca=41.6117 \
        scb=0.0399934 scc=0.00517383 m=(1)
    I1\|PM17 (I1\|net5 I1\|N_S10 \2\:net15 vdd!) g45p1svt w=(1.2e-07) \
        l=4.5e-08 nf=1 as=1.92e-14 ad=1.92e-14 ps=5.6e-07 pd=5.6e-07 \
        nrd=1.16667 nrs=1.16667 sa=6.2e-07 sb=3.45e-07 sd=160n sca=41.6117 \
        scb=0.0399934 scc=0.00517383 m=(1)
    I1\|PM1 (I1\|net9 I1\|N_S00 \2\:net17 vdd!) g45p1svt w=(1.2e-07) \
        l=4.5e-08 nf=1 as=1.92e-14 ad=1.92e-14 ps=5.6e-07 pd=5.6e-07 \
        nrd=1.16667 nrs=1.16667 sa=6.2e-07 sb=3.45e-07 sd=160n sca=41.6117 \
        scb=0.0399934 scc=0.00517383 m=(1)
    I1\|PM15 (\2\:net15 \2\:S31 \5\:I1\|net6 vdd!) g45p1svt w=(1.2e-07) \
        l=4.5e-08 nf=1 as=1.68e-14 ad=1.92e-14 ps=5.2e-07 pd=5.6e-07 \
        nrd=1.16667 nrs=1.16667 sa=8.25e-07 sb=1.4e-07 sd=160n sca=41.6117 \
        scb=0.0399934 scc=0.00517383 m=(1)
    I1\|PM3 (\2\:net17 \2\:S21 \5\:I1\|net10 vdd!) g45p1svt w=(1.2e-07) \
        l=4.5e-08 nf=1 as=1.68e-14 ad=1.92e-14 ps=5.2e-07 pd=5.6e-07 \
        nrd=1.16667 nrs=1.16667 sa=8.25e-07 sb=1.4e-07 sd=160n sca=41.6117 \
        scb=0.0399934 scc=0.00517383 m=(1)
    I1\|PM22 (\11\:I1\|net10 \4\:I1\|N_S11 I1\|net8 vdd!) g45p1svt \
        w=(1.2e-07) l=4.5e-08 nf=1 as=2.52e-14 ad=1.92e-14 ps=6.6e-07 \
        pd=5.6e-07 nrd=1.16667 nrs=1.16667 sa=2.1e-07 sb=7.55e-07 sd=160n \
        sca=41.6117 scb=0.0399934 scc=0.00517383 m=(1)
    I1\|PM8 (\9\:I1\|net9 \4\:I1\|N_S01 I1\|net3 vdd!) g45p1svt \
        w=(1.2e-07) l=4.5e-08 nf=1 as=2.52e-14 ad=1.92e-14 ps=6.6e-07 \
        pd=5.6e-07 nrd=1.16667 nrs=1.16667 sa=2.1e-07 sb=7.55e-07 sd=160n \
        sca=41.6117 scb=0.0399934 scc=0.00517383 m=(1)
    I1\|PM23 (\11\:I1\|net10 \1\:S32 I1\|net2 vdd!) g45p1svt w=(1.2e-07) \
        l=4.5e-08 nf=1 as=1.92e-14 ad=1.92e-14 ps=5.6e-07 pd=5.6e-07 \
        nrd=1.16667 nrs=1.16667 sa=4.15e-07 sb=5.5e-07 sd=160n sca=41.6117 \
        scb=0.0399934 scc=0.00517383 m=(1)
    I1\|PM9 (\9\:I1\|net9 \1\:S22 I1\|net1 vdd!) g45p1svt w=(1.2e-07) \
        l=4.5e-08 nf=1 as=1.92e-14 ad=1.92e-14 ps=5.6e-07 pd=5.6e-07 \
        nrd=1.16667 nrs=1.16667 sa=4.15e-07 sb=5.5e-07 sd=160n sca=41.6117 \
        scb=0.0399934 scc=0.00517383 m=(1)
    I1\|PM20 (I1\|net2 I1\|N_S11 \7\:I1\|net6 vdd!) g45p1svt w=(1.2e-07) \
        l=4.5e-08 nf=1 as=1.92e-14 ad=1.92e-14 ps=5.6e-07 pd=5.6e-07 \
        nrd=1.16667 nrs=1.16667 sa=6.2e-07 sb=3.45e-07 sd=160n sca=41.6117 \
        scb=0.0399934 scc=0.00517383 m=(1)
    I1\|PM6 (I1\|net1 I1\|N_S01 \5\:I1\|net5 vdd!) g45p1svt w=(1.2e-07) \
        l=4.5e-08 nf=1 as=1.92e-14 ad=1.92e-14 ps=5.6e-07 pd=5.6e-07 \
        nrd=1.16667 nrs=1.16667 sa=6.2e-07 sb=3.45e-07 sd=160n sca=41.6117 \
        scb=0.0399934 scc=0.00517383 m=(1)
    I1\|PM16 (\7\:I1\|net6 \2\:S32 \5\:I1\|net8 vdd!) g45p1svt w=(1.2e-07) \
        l=4.5e-08 nf=1 as=1.68e-14 ad=1.92e-14 ps=5.2e-07 pd=5.6e-07 \
        nrd=1.16667 nrs=1.16667 sa=8.25e-07 sb=1.4e-07 sd=160n sca=41.6117 \
        scb=0.0399934 scc=0.00517383 m=(1)
    I1\|PM5 (\5\:I1\|net5 \2\:S22 \5\:I1\|net3 vdd!) g45p1svt w=(1.2e-07) \
        l=4.5e-08 nf=1 as=1.68e-14 ad=1.92e-14 ps=5.2e-07 pd=5.6e-07 \
        nrd=1.16667 nrs=1.16667 sa=8.25e-07 sb=1.4e-07 sd=160n sca=41.6117 \
        scb=0.0399934 scc=0.00517383 m=(1)
    I1\|PM27 (\11\:I1\|net3 \4\:I1\|N_S12 \7\:net19 vdd!) g45p1svt \
        w=(1.2e-07) l=4.5e-08 nf=1 as=2.52e-14 ad=1.92e-14 ps=6.6e-07 \
        pd=5.6e-07 nrd=1.16667 nrs=1.16667 sa=2.1e-07 sb=7.55e-07 sd=160n \
        sca=41.6117 scb=0.0399934 scc=0.00517383 m=(1)
    I1\|PM13 (\9\:I1\|net1 \4\:I1\|N_S02 \7\:net21 vdd!) g45p1svt \
        w=(1.2e-07) l=4.5e-08 nf=1 as=2.52e-14 ad=1.92e-14 ps=6.6e-07 \
        pd=5.6e-07 nrd=1.16667 nrs=1.16667 sa=2.1e-07 sb=7.55e-07 sd=160n \
        sca=41.6117 scb=0.0399934 scc=0.00517383 m=(1)
    I1\|PM28 (\11\:I1\|net3 \1\:S33 net20 vdd!) g45p1svt w=(1.2e-07) \
        l=4.5e-08 nf=1 as=1.92e-14 ad=1.92e-14 ps=5.6e-07 pd=5.6e-07 \
        nrd=1.16667 nrs=1.16667 sa=4.15e-07 sb=5.5e-07 sd=160n sca=41.6117 \
        scb=0.0399934 scc=0.00517383 m=(1)
    I1\|PM14 (\9\:I1\|net1 \1\:S23 \2\:net22 vdd!) g45p1svt w=(1.2e-07) \
        l=4.5e-08 nf=1 as=1.92e-14 ad=1.92e-14 ps=5.6e-07 pd=5.6e-07 \
        nrd=1.16667 nrs=1.16667 sa=4.15e-07 sb=5.5e-07 sd=160n sca=41.6117 \
        scb=0.0399934 scc=0.00517383 m=(1)
    I1\|PM25 (net20 I1\|N_S12 \7\:I1\|net8 vdd!) g45p1svt w=(1.2e-07) \
        l=4.5e-08 nf=1 as=1.92e-14 ad=1.92e-14 ps=5.6e-07 pd=5.6e-07 \
        nrd=1.16667 nrs=1.16667 sa=6.2e-07 sb=3.45e-07 sd=160n sca=41.6117 \
        scb=0.0399934 scc=0.00517383 m=(1)
    I1\|PM11 (\2\:net22 I1\|N_S02 \5\:I1\|net2 vdd!) g45p1svt w=(1.2e-07) \
        l=4.5e-08 nf=1 as=1.92e-14 ad=1.92e-14 ps=5.6e-07 pd=5.6e-07 \
        nrd=1.16667 nrs=1.16667 sa=6.2e-07 sb=3.45e-07 sd=160n sca=41.6117 \
        scb=0.0399934 scc=0.00517383 m=(1)
    I1\|PM24 (\7\:I1\|net8 \2\:S33 \4\:net19 vdd!) g45p1svt w=(1.2e-07) \
        l=4.5e-08 nf=1 as=1.68e-14 ad=1.92e-14 ps=5.2e-07 pd=5.6e-07 \
        nrd=1.16667 nrs=1.16667 sa=8.25e-07 sb=1.4e-07 sd=160n sca=41.6117 \
        scb=0.0399934 scc=0.00517383 m=(1)
    I1\|PM10 (\5\:I1\|net2 \2\:S23 \4\:net21 vdd!) g45p1svt w=(1.2e-07) \
        l=4.5e-08 nf=1 as=1.68e-14 ad=1.92e-14 ps=5.2e-07 pd=5.6e-07 \
        nrd=1.16667 nrs=1.16667 sa=8.25e-07 sb=1.4e-07 sd=160n sca=41.6117 \
        scb=0.0399934 scc=0.00517383 m=(1)
    I6\|PM6 (\4\:net8 \4\:I6\|N_S \2\:Y1 vdd!) g45p1svt w=(1.2e-07) \
        l=4.5e-08 nf=1 as=2.52e-14 ad=1.92e-14 ps=6.6e-07 pd=5.6e-07 \
        nrd=1.16667 nrs=1.16667 sa=2.1e-07 sb=7.55e-07 sd=160n sca=41.897 \
        scb=0.0400704 scc=0.00517385 m=(1)
    I6\|PM0 (\4\:net8 \1\:S04 \1\:Y0 vdd!) g45p1svt w=(1.2e-07) l=4.5e-08 \
        nf=1 as=1.92e-14 ad=1.92e-14 ps=5.6e-07 pd=5.6e-07 nrd=1.16667 \
        nrs=1.16667 sa=4.15e-07 sb=5.5e-07 sd=160n sca=42.7422 \
        scb=0.0406409 scc=0.00517452 m=(1)
    I6\|PM7 (\6\:net22 I6\|N_S \1\:Y0 vdd!) g45p1svt w=(1.2e-07) l=4.5e-08 \
        nf=1 as=1.92e-14 ad=1.92e-14 ps=5.6e-07 pd=5.6e-07 nrd=1.16667 \
        nrs=1.16667 sa=6.2e-07 sb=3.45e-07 sd=160n sca=44.8715 \
        scb=0.0436968 scc=0.00520302 m=(1)
    I6\|PM5 (\6\:net22 \2\:S04 \5\:Y1 vdd!) g45p1svt w=(1.2e-07) l=4.5e-08 \
        nf=1 as=1.68e-14 ad=1.92e-14 ps=5.2e-07 pd=5.6e-07 nrd=1.16667 \
        nrs=1.16667 sa=8.25e-07 sb=1.4e-07 sd=160n sca=53.2651 \
        scb=0.056752 scc=0.0061893 m=(1)
    I7\|PM6 (\4\:net6 \4\:I7\|N_S \6\:Y3 vdd!) g45p1svt w=(1.2e-07) \
        l=4.5e-08 nf=1 as=2.52e-14 ad=1.92e-14 ps=6.6e-07 pd=5.6e-07 \
        nrd=1.16667 nrs=1.16667 sa=2.1e-07 sb=7.55e-07 sd=160n sca=41.897 \
        scb=0.0400704 scc=0.00517385 m=(1)
    I7\|PM0 (\4\:net6 \1\:S14 \1\:Y2 vdd!) g45p1svt w=(1.2e-07) l=4.5e-08 \
        nf=1 as=1.92e-14 ad=1.92e-14 ps=5.6e-07 pd=5.6e-07 nrd=1.16667 \
        nrs=1.16667 sa=4.15e-07 sb=5.5e-07 sd=160n sca=42.7422 \
        scb=0.0406409 scc=0.00517452 m=(1)
    I7\|PM7 (\5\:net20 I7\|N_S \1\:Y2 vdd!) g45p1svt w=(1.2e-07) l=4.5e-08 \
        nf=1 as=1.92e-14 ad=1.92e-14 ps=5.6e-07 pd=5.6e-07 nrd=1.16667 \
        nrs=1.16667 sa=6.2e-07 sb=3.45e-07 sd=160n sca=44.8715 \
        scb=0.0436968 scc=0.00520302 m=(1)
    I7\|PM5 (\5\:net20 \2\:S14 \5\:Y3 vdd!) g45p1svt w=(1.2e-07) l=4.5e-08 \
        nf=1 as=1.68e-14 ad=1.92e-14 ps=5.2e-07 pd=5.6e-07 nrd=1.16667 \
        nrs=1.16667 sa=8.25e-07 sb=1.4e-07 sd=160n sca=53.2651 \
        scb=0.056752 scc=0.0061893 m=(1)
    I8\|PM6 (\10\:net7 \4\:I8\|N_S \4\:Y5 vdd!) g45p1svt w=(1.2e-07) \
        l=4.5e-08 nf=1 as=2.52e-14 ad=1.92e-14 ps=6.6e-07 pd=5.6e-07 \
        nrd=1.16667 nrs=1.16667 sa=2.1e-07 sb=7.55e-07 sd=160n sca=41.897 \
        scb=0.0400704 scc=0.00517385 m=(1)
    I8\|PM0 (\10\:net7 \1\:S24 \1\:Y4 vdd!) g45p1svt w=(1.2e-07) l=4.5e-08 \
        nf=1 as=1.92e-14 ad=1.92e-14 ps=5.6e-07 pd=5.6e-07 nrd=1.16667 \
        nrs=1.16667 sa=4.15e-07 sb=5.5e-07 sd=160n sca=42.7422 \
        scb=0.0406409 scc=0.00517452 m=(1)
    I8\|PM7 (\2\:net21 I8\|N_S \1\:Y4 vdd!) g45p1svt w=(1.2e-07) l=4.5e-08 \
        nf=1 as=1.92e-14 ad=1.92e-14 ps=5.6e-07 pd=5.6e-07 nrd=1.16667 \
        nrs=1.16667 sa=6.2e-07 sb=3.45e-07 sd=160n sca=44.8715 \
        scb=0.0436968 scc=0.00520302 m=(1)
    I8\|PM5 (\2\:net21 \2\:S24 \5\:Y5 vdd!) g45p1svt w=(1.2e-07) l=4.5e-08 \
        nf=1 as=1.68e-14 ad=1.92e-14 ps=5.2e-07 pd=5.6e-07 nrd=1.16667 \
        nrs=1.16667 sa=8.25e-07 sb=1.4e-07 sd=160n sca=53.2651 \
        scb=0.056752 scc=0.0061893 m=(1)
    I9\|PM6 (\11\:net5 \4\:I9\|N_S \4\:Y7 vdd!) g45p1svt w=(1.2e-07) \
        l=4.5e-08 nf=1 as=2.52e-14 ad=1.92e-14 ps=6.6e-07 pd=5.6e-07 \
        nrd=1.16667 nrs=1.16667 sa=2.1e-07 sb=7.55e-07 sd=160n sca=41.897 \
        scb=0.0400704 scc=0.00517385 m=(1)
    I9\|PM0 (\11\:net5 \1\:S34 \1\:Y6 vdd!) g45p1svt w=(1.2e-07) l=4.5e-08 \
        nf=1 as=1.92e-14 ad=1.92e-14 ps=5.6e-07 pd=5.6e-07 nrd=1.16667 \
        nrs=1.16667 sa=4.15e-07 sb=5.5e-07 sd=160n sca=42.7422 \
        scb=0.0406409 scc=0.00517452 m=(1)
    I9\|PM7 (\2\:net19 I9\|N_S \1\:Y6 vdd!) g45p1svt w=(1.2e-07) l=4.5e-08 \
        nf=1 as=1.92e-14 ad=1.92e-14 ps=5.6e-07 pd=5.6e-07 nrd=1.16667 \
        nrs=1.16667 sa=6.2e-07 sb=3.45e-07 sd=160n sca=44.8715 \
        scb=0.0436968 scc=0.00520302 m=(1)
    I9\|PM5 (\2\:net19 \2\:S34 \5\:Y7 vdd!) g45p1svt w=(1.2e-07) l=4.5e-08 \
        nf=1 as=1.68e-14 ad=1.92e-14 ps=5.2e-07 pd=5.6e-07 nrd=1.16667 \
        nrs=1.16667 sa=8.25e-07 sb=1.4e-07 sd=160n sca=53.2651 \
        scb=0.056752 scc=0.0061893 m=(1)
    I2\|PM6 (\2\:X0 \2\:I2\|N_S net18 vdd!) g45p1svt w=(1.2e-07) l=4.5e-08 \
        nf=1 as=2.52e-14 ad=1.92e-14 ps=6.6e-07 pd=5.6e-07 nrd=1.16667 \
        nrs=1.16667 sa=2.1e-07 sb=7.55e-07 sd=160n sca=41.897 \
        scb=0.0400704 scc=0.00517385 m=(1)
    I2\|PM0 (\2\:X0 \6\:S00 \6\:net4 vdd!) g45p1svt w=(1.2e-07) l=4.5e-08 \
        nf=1 as=1.92e-14 ad=1.92e-14 ps=5.6e-07 pd=5.6e-07 nrd=1.16667 \
        nrs=1.16667 sa=4.15e-07 sb=5.5e-07 sd=160n sca=42.7422 \
        scb=0.0406409 scc=0.00517452 m=(1)
    I2\|PM7 (\2\:X1 \5\:I2\|N_S \6\:net4 vdd!) g45p1svt w=(1.2e-07) \
        l=4.5e-08 nf=1 as=1.92e-14 ad=1.92e-14 ps=5.6e-07 pd=5.6e-07 \
        nrd=1.16667 nrs=1.16667 sa=6.2e-07 sb=3.45e-07 sd=160n sca=44.8715 \
        scb=0.0436968 scc=0.00520302 m=(1)
    I2\|PM5 (\2\:X1 \5\:S00 \4\:net18 vdd!) g45p1svt w=(1.2e-07) l=4.5e-08 \
        nf=1 as=1.68e-14 ad=1.92e-14 ps=5.2e-07 pd=5.6e-07 nrd=1.16667 \
        nrs=1.16667 sa=8.25e-07 sb=1.4e-07 sd=160n sca=53.2651 \
        scb=0.056752 scc=0.0061893 m=(1)
    I3\|PM6 (\2\:X2 \2\:I3\|N_S net16 vdd!) g45p1svt w=(1.2e-07) l=4.5e-08 \
        nf=1 as=2.52e-14 ad=1.92e-14 ps=6.6e-07 pd=5.6e-07 nrd=1.16667 \
        nrs=1.16667 sa=2.1e-07 sb=7.55e-07 sd=160n sca=41.897 \
        scb=0.0400704 scc=0.00517385 m=(1)
    I3\|PM0 (\2\:X2 \6\:S10 \6\:net2 vdd!) g45p1svt w=(1.2e-07) l=4.5e-08 \
        nf=1 as=1.92e-14 ad=1.92e-14 ps=5.6e-07 pd=5.6e-07 nrd=1.16667 \
        nrs=1.16667 sa=4.15e-07 sb=5.5e-07 sd=160n sca=42.7422 \
        scb=0.0406409 scc=0.00517452 m=(1)
    I3\|PM7 (\2\:X3 \5\:I3\|N_S \6\:net2 vdd!) g45p1svt w=(1.2e-07) \
        l=4.5e-08 nf=1 as=1.92e-14 ad=1.92e-14 ps=5.6e-07 pd=5.6e-07 \
        nrd=1.16667 nrs=1.16667 sa=6.2e-07 sb=3.45e-07 sd=160n sca=44.8715 \
        scb=0.0436968 scc=0.00520302 m=(1)
    I3\|PM5 (\2\:X3 \5\:S10 \4\:net16 vdd!) g45p1svt w=(1.2e-07) l=4.5e-08 \
        nf=1 as=1.68e-14 ad=1.92e-14 ps=5.2e-07 pd=5.6e-07 nrd=1.16667 \
        nrs=1.16667 sa=8.25e-07 sb=1.4e-07 sd=160n sca=53.2651 \
        scb=0.056752 scc=0.0061893 m=(1)
    I4\|PM6 (\2\:X4 \2\:I4\|N_S \7\:net17 vdd!) g45p1svt w=(1.2e-07) \
        l=4.5e-08 nf=1 as=2.52e-14 ad=1.92e-14 ps=6.6e-07 pd=5.6e-07 \
        nrd=1.16667 nrs=1.16667 sa=2.1e-07 sb=7.55e-07 sd=160n sca=41.897 \
        scb=0.0400704 scc=0.00517385 m=(1)
    I4\|PM0 (\2\:X4 \6\:S20 \2\:net3 vdd!) g45p1svt w=(1.2e-07) l=4.5e-08 \
        nf=1 as=1.92e-14 ad=1.92e-14 ps=5.6e-07 pd=5.6e-07 nrd=1.16667 \
        nrs=1.16667 sa=4.15e-07 sb=5.5e-07 sd=160n sca=42.7422 \
        scb=0.0406409 scc=0.00517452 m=(1)
    I4\|PM7 (\2\:X5 \5\:I4\|N_S \2\:net3 vdd!) g45p1svt w=(1.2e-07) \
        l=4.5e-08 nf=1 as=1.92e-14 ad=1.92e-14 ps=5.6e-07 pd=5.6e-07 \
        nrd=1.16667 nrs=1.16667 sa=6.2e-07 sb=3.45e-07 sd=160n sca=44.8715 \
        scb=0.0436968 scc=0.00520302 m=(1)
    I4\|PM5 (\2\:X5 \5\:S20 \6\:net17 vdd!) g45p1svt w=(1.2e-07) l=4.5e-08 \
        nf=1 as=1.68e-14 ad=1.92e-14 ps=5.2e-07 pd=5.6e-07 nrd=1.16667 \
        nrs=1.16667 sa=8.25e-07 sb=1.4e-07 sd=160n sca=53.2651 \
        scb=0.056752 scc=0.0061893 m=(1)
    I5\|PM6 (\2\:X6 \2\:I5\|N_S \7\:net15 vdd!) g45p1svt w=(1.2e-07) \
        l=4.5e-08 nf=1 as=2.52e-14 ad=1.92e-14 ps=6.6e-07 pd=5.6e-07 \
        nrd=1.16667 nrs=1.16667 sa=2.1e-07 sb=7.55e-07 sd=160n sca=41.897 \
        scb=0.0400704 scc=0.00517385 m=(1)
    I5\|PM0 (\2\:X6 \6\:S30 \3\:net1 vdd!) g45p1svt w=(1.2e-07) l=4.5e-08 \
        nf=1 as=1.92e-14 ad=1.92e-14 ps=5.6e-07 pd=5.6e-07 nrd=1.16667 \
        nrs=1.16667 sa=4.15e-07 sb=5.5e-07 sd=160n sca=42.7422 \
        scb=0.0406409 scc=0.00517452 m=(1)
    I5\|PM7 (\2\:X7 \5\:I5\|N_S \3\:net1 vdd!) g45p1svt w=(1.2e-07) \
        l=4.5e-08 nf=1 as=1.92e-14 ad=1.92e-14 ps=5.6e-07 pd=5.6e-07 \
        nrd=1.16667 nrs=1.16667 sa=6.2e-07 sb=3.45e-07 sd=160n sca=44.8715 \
        scb=0.0436968 scc=0.00520302 m=(1)
    I5\|PM5 (\2\:X7 \5\:S30 \6\:net15 vdd!) g45p1svt w=(1.2e-07) l=4.5e-08 \
        nf=1 as=1.68e-14 ad=1.92e-14 ps=5.2e-07 pd=5.6e-07 nrd=1.16667 \
        nrs=1.16667 sa=8.25e-07 sb=1.4e-07 sd=160n sca=53.2651 \
        scb=0.056752 scc=0.0061893 m=(1)
    C1 (\6\:S14 \5\:I7\|N_S) capacitor c=8.6369e-19
    C2 (\140\:gnd! net6) capacitor c=4.00771e-18
    C3 (X7 S30) capacitor c=2.9971e-17
    C4 (\8\:net15 \4\:S30) capacitor c=4.60463e-18
    C5 (I1\|net8 \8\:I1\|net10) capacitor c=1.61396e-16
    C6 (\2\:I1\|net8 \5\:I1\|net8) capacitor c=5.03702e-18
    C7 (\4\:net3 \5\:X0) capacitor c=9.22426e-18
    C8 (S13 S03) capacitor c=9.24266e-18
    C9 (\8\:I0\|net3 \8\:net6) capacitor c=5.23564e-17
    C10 (S30 S31) capacitor c=1.2031e-16
    C11 (S12 S02) capacitor c=1.5032e-17
    C12 (\6\:S24 \4\:S14) capacitor c=2.26285e-17
    C13 (S14 Y1) capacitor c=1.07537e-16
    C14 (\8\:I1\|N_S11 \4\:S32) capacitor c=4.6447e-18
    C15 (\2\:net7 \3\:S03) capacitor c=1.25858e-17
    C16 (\1\:Y5 \3\:S24) capacitor c=4.82644e-18
    C17 (Y2 S14) capacitor c=1.68434e-17
    C18 (X6 X7) capacitor c=2.22622e-18
    C19 (\6\:I1\|net3 \7\:net21) capacitor c=3.90404e-18
    C20 (\6\:net6 \7\:I0\|net8) capacitor c=7.99661e-17
    C21 (\6\:X4 \4\:S20) capacitor c=3.88196e-18
    C22 (\5\:X2 \1\:X3) capacitor c=2.53021e-17
    C23 (\6\:X2 \5\:net16) capacitor c=1.65082e-17
    C24 (\10\:I1\|net6 \4\:I1\|net2) capacitor c=1.90574e-17
    C25 (\8\:net22 \10\:S22) capacitor c=2.65108e-17
    C26 (\6\:I1\|net3 vdd!) capacitor c=3.68405e-18
    C27 (\2\:net8 \3\:Y0) capacitor c=4.66555e-17
    C28 (\7\:net5 \3\:S34) capacitor c=1.13061e-17
    C29 (S11 X0) capacitor c=1.106e-17
    C30 (\6\:I0\|net2 net7) capacitor c=2.32962e-17
    C31 (\6\:S33 \7\:I1\|N_S12) capacitor c=9.12465e-17
    C32 (\140\:gnd! \5\:net20) capacitor c=2.5469e-16
    C33 (\6\:net6 \4\:I0\|N_S12) capacitor c=2.66735e-18
    C34 (X0 X1) capacitor c=2.83038e-18
    C35 (\4\:net22 \10\:S22) capacitor c=1.95566e-16
    C36 (\10\:net5 \2\:Y7) capacitor c=9.40069e-18
    C37 (S13 vdd!) capacitor c=5.27321e-18
    C38 (net8 \2\:I6\|N_S) capacitor c=8.24519e-18
    C39 (\8\:net3 \7\:I0\|N_S00) capacitor c=8.04376e-18
    C40 (X2 S10) capacitor c=1.56049e-18
    C41 (\4\:Y5 \4\:I8\|N_S) capacitor c=2.42313e-18
    C42 (net4 \6\:net3) capacitor c=2.19039e-18
    C43 (\3\:I1\|net9 \3\:I1\|N_S00) capacitor c=1.1944e-18
    C44 (S32 I1\|net8) capacitor c=5.27658e-18
    C45 (\2\:I1\|net8 S33) capacitor c=1.212e-16
    C46 (S21 X2) capacitor c=1.09298e-17
    C47 (\6\:S31 \4\:S21) capacitor c=1.58157e-17
    C48 (X5 S20) capacitor c=3.95775e-17
    C49 (\2\:S33 \5\:S34) capacitor c=4.64723e-18
    C50 (\4\:Y7 \8\:net5) capacitor c=1.04862e-16
    C51 (\2\:net18 net16) capacitor c=7.71749e-18
    C52 (\3\:S04 \2\:I6\|N_S) capacitor c=5.24318e-17
    C53 (X4 X5) capacitor c=2.78398e-18
    C54 (\6\:net4 \6\:S00) capacitor c=2.2134e-17
    C55 (\8\:net3 I2\|N_S) capacitor c=6.9704e-18
    C56 (X2 X3) capacitor c=2.68666e-18
    C57 (\8\:I0\|net3 \2\:I0\|N_S12) capacitor c=8.29208e-19
    C58 (\2\:Y4 \4\:I8\|N_S) capacitor c=1.62741e-18
    C59 (\9\:S22 \5\:I1\|N_S02) capacitor c=4.31124e-18
    C60 (\4\:net3 \5\:net16) capacitor c=3.28683e-18
    C61 (S20 S21) capacitor c=1.73493e-16
    C62 (\3\:S11 \5\:S12) capacitor c=1.23797e-18
    C63 (\2\:I1\|net8 \2\:I1\|net3) capacitor c=4.67304e-18
    C64 (\7\:I0\|net6 \1\:S12) capacitor c=2.74877e-18
    C65 (\7\:net20 \4\:Y7) capacitor c=3.45944e-18
    C66 (\3\:S01 \4\:S02) capacitor c=6.14689e-18
    C67 (net22 \2\:I1\|N_S02) capacitor c=1.06502e-18
    C68 (\1\:S11 I0\|N_S10) capacitor c=2.17725e-17
    C69 (\2\:I1\|net3 \3\:S22) capacitor c=1.36793e-17
    C70 (\3\:I1\|net1 \6\:I1\|net5) capacitor c=1.77925e-18
    C71 (\6\:net21 \5\:S24) capacitor c=4.35848e-18
    C72 (Y1 Y0) capacitor c=8.19528e-18
    C73 (\1\:S30 \2\:net15) capacitor c=8.53379e-18
    C74 (\6\:S11 \3\:S00) capacitor c=1.35625e-17
    C75 (\10\:S22 \2\:net5) capacitor c=3.22354e-18
    C76 (\3\:I0\|net1 vdd!) capacitor c=8.86199e-18
    C77 (\8\:I1\|net8 \2\:I1\|N_S12) capacitor c=2.27253e-18
    C78 (\2\:X2 \6\:S10) capacitor c=1.99607e-18
    C79 (\6\:I0\|net2 \7\:S03) capacitor c=2.12764e-18
    C80 (\6\:S34 \137\:gnd!) capacitor c=3.96894e-18
    C81 (\3\:I0\|net2 vdd!) capacitor c=5.47372e-18
    C82 (\5\:net3 \6\:I0\|net10) capacitor c=1.794e-17
    C83 (\9\:I1\|N_S12 \112\:gnd!) capacitor c=2.07646e-17
    C84 (Y7 Y6) capacitor c=2.19992e-17
    C85 (\3\:I1\|N_S02 \7\:S23) capacitor c=2.73822e-17
    C86 (\7\:net15 \9\:I5\|N_S) capacitor c=1.86216e-18
    C87 (\159\:gnd! \6\:net3) capacitor c=1.67527e-18
    C88 (\109\:vdd! net7) capacitor c=4.03879e-18
    C89 (\3\:X2 \7\:S10) capacitor c=4.90408e-18
    C90 (\3\:I1\|net1 vdd!) capacitor c=3.50275e-18
    C91 (S30 \5\:I5\|N_S) capacitor c=9.5738e-19
    C92 (\3\:I0\|net2 \7\:I0\|net6) capacitor c=7.58696e-17
    C93 (\3\:I1\|net2 vdd!) capacitor c=4.90093e-18
    C94 (\9\:I9\|N_S \133\:gnd!) capacitor c=2.09636e-17
    C95 (\8\:I0\|net9 \7\:I0\|N_S01) capacitor c=2.24261e-18
    C96 (\8\:net4 \7\:S00) capacitor c=3.25525e-18
    C97 (\8\:I0\|net9 S02) capacitor c=7.35181e-19
    C98 (\2\:X6 \7\:net15) capacitor c=5.26033e-17
    C99 (\7\:net15 \6\:I5\|N_S) capacitor c=2.21691e-18
    C100 (net5 \7\:S13) capacitor c=2.0355e-18
    C101 (\3\:I0\|net9 S02) capacitor c=1.13647e-18
    C102 (I0\|N_S02 \2\:S03) capacitor c=2.16088e-17
    C103 (\8\:I0\|net9 vdd!) capacitor c=6.21313e-18
    C104 (\7\:I0\|N_S00 \5\:S01) capacitor c=1.50947e-17
    C105 (\2\:net5 \2\:S13) capacitor c=1.15556e-17
    C106 (\140\:gnd! \2\:Y2) capacitor c=1.79553e-17
    C107 (net1 \3\:I5\|N_S) capacitor c=4.6767e-18
    C108 (I1\|net8 \4\:S32) capacitor c=6.90282e-18
    C109 (\8\:I1\|net9 \5\:I1\|N_S01) capacitor c=9.8452e-18
    C110 (\10\:I0\|net10 vdd!) capacitor c=3.55076e-18
    C111 (\2\:net16 \3\:I3\|N_S) capacitor c=2.78422e-18
    C112 (X3 S10) capacitor c=3.17504e-17
    C113 (\7\:I0\|N_S01 \47\:vdd!) capacitor c=3.70257e-17
    C114 (\1\:X5 \3\:I4\|N_S) capacitor c=1.82906e-18
    C115 (\6\:net5 \6\:Y3) capacitor c=2.34924e-18
    C116 (\4\:net3 \5\:X2) capacitor c=1.27412e-17
    C117 (\2\:net17 \2\:S21) capacitor c=1.42393e-17
    C118 (\8\:I1\|net9 vdd!) capacitor c=2.82356e-18
    C119 (\7\:net1 \42\:gnd!) capacitor c=2.84084e-18
    C120 (\6\:I1\|net6 \6\:net16) capacitor c=4.32413e-17
    C121 (\3\:net7 \4\:I0\|N_S02) capacitor c=2.40414e-18
    C122 (\7\:net1 \6\:net2) capacitor c=4.40366e-18
    C123 (Y4 S22) capacitor c=1.5899e-17
    C124 (\32\:vdd! \5\:S11) capacitor c=6.02704e-18
    C125 (\10\:I1\|net10 vdd!) capacitor c=3.21613e-18
    C126 (\109\:vdd! \9\:I6\|N_S) capacitor c=8.90357e-19
    C127 (\2\:I0\|net10 \2\:S01) capacitor c=1.14349e-17
    C128 (\2\:net4 \5\:net3) capacitor c=1.23924e-17
    C129 (\10\:I0\|net3 \5\:I0\|net2) capacitor c=1.30876e-18
    C130 (\6\:S34 \4\:S24) capacitor c=2.02315e-17
    C131 (\4\:net6 \5\:I7\|N_S) capacitor c=9.46028e-17
    C132 (\4\:I1\|net9 net17) capacitor c=3.26102e-17
    C133 (\8\:I1\|net5 \6\:I1\|net9) capacitor c=2.14801e-17
    C134 (\4\:Y7 \4\:S34) capacitor c=2.77317e-18
    C135 (S32 \6\:I1\|N_S11) capacitor c=1.2935e-17
    C136 (\7\:I0\|N_S01 S02) capacitor c=1.55593e-17
    C137 (S14 \3\:S04) capacitor c=6.20599e-18
    C138 (S30 \4\:S20) capacitor c=1.56325e-18
    C139 (\146\:gnd! \9\:I5\|N_S) capacitor c=4.48565e-18
    C140 (\1\:S21 I1\|N_S00) capacitor c=2.1478e-17
    C141 (S10 S11) capacitor c=1.61523e-16
    C142 (\3\:S14 \2\:I7\|N_S) capacitor c=5.24319e-17
    C143 (\9\:S22 \10\:I0\|net6) capacitor c=3.15033e-17
    C144 (\3\:I1\|net9 \6\:I0\|net6) capacitor c=9.58582e-18
    C145 (\7\:Y7 \7\:net20) capacitor c=2.90423e-17
    C146 (\3\:I1\|net9 \7\:I1\|N_S01) capacitor c=6.42152e-18
    C147 (\5\:X0 \5\:net18) capacitor c=2.21989e-17
    C148 (\7\:net1 \8\:net3) capacitor c=7.56874e-18
    C149 (\1\:S13 \3\:S03) capacitor c=6.34434e-18
    C150 (\7\:I7\|N_S \92\:vdd!) capacitor c=3.96507e-17
    C151 (\7\:net1 \4\:S11) capacitor c=2.75462e-18
    C152 (S13 \5\:S03) capacitor c=1.97478e-18
    C153 (\6\:I0\|net5 \3\:I0\|N_S01) capacitor c=1.313e-18
    C154 (I0\|N_S12 \2\:S13) capacitor c=2.20571e-17
    C155 (\6\:net6 \3\:I0\|N_S12) capacitor c=1.04495e-18
    C156 (\8\:I1\|net6 \7\:S32) capacitor c=2.12586e-18
    C157 (\8\:I0\|net10 \7\:S12) capacitor c=4.85972e-18
    C158 (\4\:I1\|net1 \7\:S22) capacitor c=3.05594e-18
    C159 (\2\:net20 \7\:I1\|net8) capacitor c=1.72425e-17
    C160 (\2\:Y3 I7\|N_S) capacitor c=1.49817e-18
    C161 (\2\:net8 \3\:S04) capacitor c=9.80097e-19
    C162 (\6\:net4 \7\:S00) capacitor c=2.19095e-18
    C163 (\7\:I0\|N_S01 \6\:S02) capacitor c=1.62953e-18
    C164 (\5\:I1\|net2 \6\:net21) capacitor c=7.5919e-17
    C165 (\5\:I0\|N_S00 \1\:S01) capacitor c=9.83024e-18
    C166 (\9\:I1\|N_S02 \4\:S23) capacitor c=4.89505e-18
    C167 (\8\:I1\|net9 \57\:vdd!) capacitor c=2.19007e-18
    C168 (\10\:I0\|net8 \6\:net5) capacitor c=2.40891e-17
    C169 (\5\:net1 \3\:I0\|N_S10) capacitor c=1.2853e-18
    C170 (\6\:I0\|net5 \3\:I0\|net3) capacitor c=2.34074e-17
    C171 (\148\:gnd! \4\:net17) capacitor c=3.20248e-18
    C172 (\10\:S22 \6\:S24) capacitor c=1.51469e-17
    C173 (\112\:gnd! \4\:S33) capacitor c=7.51559e-18
    C174 (\5\:I0\|N_S02 \6\:net8) capacitor c=1.12283e-17
    C175 (\4\:Y7 \4\:I9\|N_S) capacitor c=2.23665e-18
    C176 (\4\:I0\|net9 \3\:I0\|N_S00) capacitor c=4.87284e-18
    C177 (\3\:S11 \4\:S12) capacitor c=5.96972e-18
    C178 (\2\:net22 \4\:I1\|N_S02) capacitor c=2.58198e-18
    C179 (\4\:Y6 \10\:net5) capacitor c=2.41285e-17
    C180 (\3\:I0\|net1 \5\:S03) capacitor c=7.84834e-19
    C181 (\10\:I1\|net3 \6\:I1\|net1) capacitor c=1.30735e-17
    C182 (\4\:I1\|net5 \7\:S31) capacitor c=3.15576e-18
    C183 (\9\:I1\|N_S12 \7\:net19) capacitor c=1.85751e-18
    C184 (\158\:gnd! \4\:net2) capacitor c=4.88315e-18
    C185 (\3\:I1\|N_S12 \7\:S33) capacitor c=2.74514e-17
    C186 (\111\:vdd! \6\:net21) capacitor c=3.07417e-17
    C187 (\13\:net5 \5\:I7\|N_S) capacitor c=8.63081e-19
    C188 (\10\:net5 \4\:I9\|N_S) capacitor c=1.03606e-17
    C189 (\2\:net21 \6\:S24) capacitor c=4.69111e-17
    C190 (\7\:net18 \7\:S21) capacitor c=4.74663e-18
    C191 (net21 \3\:S24) capacitor c=2.02157e-18
    C192 (\7\:I1\|N_S02 \77\:vdd!) capacitor c=3.7089e-17
    C193 (net6 \4\:net20) capacitor c=1.29254e-17
    C194 (\3\:I1\|net5 \3\:I1\|N_S10) capacitor c=1.14813e-18
    C195 (\7\:net5 \1\:Y7) capacitor c=5.13512e-17
    C196 (I1\|N_S02 \2\:S23) capacitor c=2.16607e-17
    C197 (\5\:I1\|N_S12 \6\:net19) capacitor c=2.30135e-18
    C198 (\3\:I1\|net3 \2\:I1\|net3) capacitor c=5.12406e-18
    C199 (\3\:Y1 I6\|N_S) capacitor c=1.62557e-18
    C200 (\6\:S21 \3\:S10) capacitor c=2.36321e-17
    C201 (\1\:Y7 \3\:S34) capacitor c=5.03588e-18
    C202 (net4 \5\:net3) capacitor c=1.22449e-17
    C203 (\2\:net1 S30) capacitor c=1.83743e-17
    C204 (S33 \7\:net19) capacitor c=5.36155e-18
    C205 (\3\:I1\|net10 \6\:net18) capacitor c=1.90437e-17
    C206 (\2\:net16 S30) capacitor c=5.93283e-18
    C207 (\1\:S31 I1\|N_S10) capacitor c=2.17441e-17
    C208 (\2\:Y1 \5\:S04) capacitor c=1.4063e-18
    C209 (\2\:net18 \2\:net16) capacitor c=7.28528e-18
    C210 (S11 \3\:net18) capacitor c=2.18189e-17
    C211 (\10\:I0\|net3 \7\:I0\|net8) capacitor c=5.7393e-18
    C212 (\9\:S22 I0\|net8) capacitor c=5.54546e-18
    C213 (\5\:I1\|net5 \1\:S22) capacitor c=2.79451e-18
    C214 (\2\:X1 \6\:S00) capacitor c=3.30411e-18
    C215 (\9\:I2\|N_S \3\:S00) capacitor c=4.68057e-18
    C216 (\4\:Y1 \2\:I6\|N_S) capacitor c=3.61624e-18
    C217 (\134\:gnd! \4\:S24) capacitor c=5.79505e-18
    C218 (\2\:Y1 \5\:I6\|N_S) capacitor c=1.69556e-17
    C219 (\1\:S23 \3\:S13) capacitor c=5.42035e-18
    C220 (\7\:net1 I3\|N_S) capacitor c=6.17896e-18
    C221 (\8\:I0\|net2 \5\:I0\|net1) capacitor c=1.51335e-17
    C222 (\8\:net3 vdd!) capacitor c=9.67311e-18
    C223 (\6\:I1\|net10 \2\:net15) capacitor c=1.71258e-17
    C224 (\3\:S24 \2\:I8\|N_S) capacitor c=5.24313e-17
    C225 (\4\:net3 net18) capacitor c=1.54558e-18
    C226 (net6 \2\:I7\|N_S) capacitor c=7.92434e-18
    C227 (\12\:net5 S14) capacitor c=6.2229e-17
    C228 (\7\:net1 vdd!) capacitor c=2.94445e-18
    C229 (\21\:vdd! \9\:I0\|N_S00) capacitor c=3.13424e-17
    C230 (\8\:I0\|net1 \5\:I0\|N_S02) capacitor c=1.2679e-17
    C231 (\4\:net22 \2\:Y5) capacitor c=6.11665e-18
    C232 (\6\:net2 \6\:S10) capacitor c=1.81544e-17
    C233 (\13\:net5 S14) capacitor c=6.71627e-17
    C234 (\21\:vdd! \4\:net4) capacitor c=5.64016e-18
    C235 (\3\:I0\|net9 vdd!) capacitor c=8.53143e-18
    C236 (\3\:I0\|net9 \8\:net3) capacitor c=3.48867e-17
    C237 (\4\:net15 \3\:I5\|N_S) capacitor c=6.93487e-18
    C238 (net4 \3\:S01) capacitor c=9.45962e-18
    C239 (\4\:Y2 S14) capacitor c=2.00627e-18
    C240 (\158\:gnd! \9\:I0\|N_S10) capacitor c=8.97224e-18
    C241 (\7\:net7 \5\:net20) capacitor c=1.86792e-17
    C242 (\3\:S31 \5\:S32) capacitor c=1.17478e-18
    C243 (\2\:net22 \5\:I1\|net2) capacitor c=7.41204e-17
    C244 (\3\:I0\|net5 vdd!) capacitor c=4.67115e-18
    C245 (\7\:net1 \158\:gnd!) capacitor c=5.3419e-17
    C246 (\2\:Y2 S14) capacitor c=1.30278e-18
    C247 (\5\:I0\|net5 \2\:I0\|N_S01) capacitor c=8.73444e-19
    C248 (\8\:net3 \2\:S01) capacitor c=9.15945e-18
    C249 (\6\:I1\|net3 \2\:I1\|net3) capacitor c=1.01448e-17
    C250 (\3\:I1\|net9 vdd!) capacitor c=3.78135e-18
    C251 (\2\:X4 \6\:S20) capacitor c=1.95008e-18
    C252 (I1\|N_S12 \2\:S33) capacitor c=2.20316e-17
    C253 (\2\:S11 \3\:S01) capacitor c=6.7428e-18
    C254 (\2\:I0\|net3 \2\:S02) capacitor c=1.15132e-17
    C255 (\6\:net5 \6\:S23) capacitor c=3.24624e-18
    C256 (\159\:gnd! \4\:S01) capacitor c=2.64404e-18
    C257 (\3\:I1\|net5 vdd!) capacitor c=4.59432e-18
    C258 (\8\:net3 \2\:X1) capacitor c=5.53344e-18
    C259 (\6\:I0\|net8 \9\:I0\|N_S12) capacitor c=3.56859e-18
    C260 (\6\:I1\|net1 \2\:I1\|N_S02) capacitor c=8.09368e-19
    C261 (net5 \4\:I0\|N_S12) capacitor c=2.42889e-18
    C262 (\148\:gnd! \4\:S21) capacitor c=3.80969e-18
    C263 (\7\:I1\|N_S10 I1\|net6) capacitor c=9.63195e-19
    C264 (\7\:net21 \7\:S23) capacitor c=2.04708e-18
    C265 (X0 \4\:S00) capacitor c=2.03039e-18
    C266 (\10\:I1\|net10 \5\:I1\|N_S11) capacitor c=1.03059e-17
    C267 (net2 \7\:net1) capacitor c=1.37467e-17
    C268 (\1\:X5 net3) capacitor c=3.30202e-17
    C269 (\9\:net18 vdd!) capacitor c=4.25121e-18
    C270 (\2\:Y0 \6\:net22) capacitor c=4.98033e-17
    C271 (\5\:I0\|N_S10 \1\:S11) capacitor c=1.01242e-17
    C272 (\6\:X6 \4\:S30) capacitor c=3.88196e-18
    C273 (S12 vdd!) capacitor c=5.02154e-18
    C274 (\7\:I0\|N_S10 \5\:S11) capacitor c=1.53392e-17
    C275 (\8\:net8 \7\:S03) capacitor c=3.16552e-18
    C276 (\2\:net15 \2\:S31) capacitor c=1.36174e-17
    C277 (\6\:net19 \2\:I1\|N_S12) capacitor c=3.42084e-18
    C278 (\6\:I0\|net9 \3\:I0\|net1) capacitor c=8.9981e-18
    C279 (\8\:I0\|net8 \7\:S13) capacitor c=2.27988e-18
    C280 (\119\:gnd! \4\:S04) capacitor c=9.80179e-18
    C281 (\8\:I1\|net2 \5\:I1\|N_S12) capacitor c=7.89938e-18
    C282 (\4\:I0\|N_S00 \1\:S01) capacitor c=1.5793e-17
    C283 (\2\:I0\|net3 \2\:I0\|N_S01) capacitor c=3.24686e-18
    C284 (\2\:X6 S30) capacitor c=3.99907e-18
    C285 (\2\:net5 \3\:S13) capacitor c=1.24214e-17
    C286 (\2\:X7 S30) capacitor c=3.10326e-17
    C287 (\2\:I0\|net10 \5\:I0\|net10) capacitor c=2.88826e-18
    C288 (\3\:S21 \4\:S22) capacitor c=7.11326e-18
    C289 (\8\:I0\|net10 \4\:I0\|net2) capacitor c=5.12559e-17
    C290 (\37\:vdd! \5\:S21) capacitor c=6.31164e-18
    C291 (\1\:S33 \3\:S23) capacitor c=7.12834e-18
    C292 (\159\:gnd! \2\:net4) capacitor c=1.1131e-17
    C293 (\6\:net3 I0\|N_S00) capacitor c=8.06512e-18
    C294 (S33 \7\:I1\|N_S12) capacitor c=1.3184e-17
    C295 (\3\:I1\|net1 \5\:I1\|net5) capacitor c=7.60782e-17
    C296 (\10\:net7 \5\:I8\|N_S) capacitor c=5.83737e-18
    C297 (\4\:net22 \4\:Y5) capacitor c=4.14277e-18
    C298 (\148\:gnd! \3\:I1\|net9) capacitor c=1.72267e-18
    C299 (\7\:net20 \3\:I9\|N_S) capacitor c=4.04178e-18
    C300 (\5\:X4 \1\:X5) capacitor c=2.61622e-17
    C301 (\10\:I0\|net10 \6\:S12) capacitor c=1.34306e-18
    C302 (\1\:S03 I0\|N_S02) capacitor c=2.19739e-17
    C303 (\10\:I0\|net10 \6\:I0\|N_S11) capacitor c=6.8782e-18
    C304 (\2\:net18 S11) capacitor c=1.15382e-16
    C305 (\2\:net1 \2\:net16) capacitor c=7.4528e-17
    C306 (\159\:gnd! \4\:net2) capacitor c=1.48042e-17
    C307 (\2\:Y3 \3\:S14) capacitor c=3.67505e-18
    C308 (\3\:S34 \2\:I9\|N_S) capacitor c=5.25095e-17
    C309 (\9\:I1\|N_S01 \77\:gnd!) capacitor c=2.22836e-17
    C310 (\1\:S10 \3\:S00) capacitor c=2.15926e-17
    C311 (\5\:net20 S14) capacitor c=3.51019e-17
    C312 (\2\:net22 \3\:I1\|N_S02) capacitor c=1.06016e-18
    C313 (\3\:I0\|net9 \2\:S01) capacitor c=1.06971e-18
    C314 (\3\:I1\|net2 \8\:I1\|net6) capacitor c=1.77925e-18
    C315 (\2\:net1 S11) capacitor c=2.07213e-18
    C316 (\8\:net5 net19) capacitor c=1.30811e-17
    C317 (\1\:Y2 S14) capacitor c=7.25954e-18
    C318 (net20 \4\:I1\|N_S12) capacitor c=2.00452e-18
    C319 (\7\:net16 \3\:I1\|N_S10) capacitor c=9.7795e-18
    C320 (\2\:net6 \3\:Y2) capacitor c=4.4757e-17
    C321 (\3\:net7 \6\:I0\|net1) capacitor c=1.63619e-16
    C322 (\140\:gnd! \1\:Y3) capacitor c=4.92758e-18
    C323 (\3\:X2 \6\:net2) capacitor c=6.44009e-18
    C324 (\6\:I1\|net1 net22) capacitor c=5.39355e-17
    C325 (\7\:net7 \2\:net21) capacitor c=2.21555e-18
    C326 (\6\:I0\|net3 \4\:S03) capacitor c=3.14316e-18
    C327 (\4\:net22 \6\:S23) capacitor c=1.67955e-17
    C328 (\3\:X4 \7\:S20) capacitor c=4.90408e-18
    C329 (\6\:I1\|net10 \3\:I1\|net5) capacitor c=7.06635e-17
    C330 (\2\:I1\|net6 \6\:S32) capacitor c=6.05161e-17
    C331 (\5\:X0 S11) capacitor c=4.1752e-18
    C332 (\2\:net1 \7\:S30) capacitor c=3.07296e-18
    C333 (\8\:net2 \7\:S10) capacitor c=3.2158e-18
    C334 (\6\:S31 \3\:S20) capacitor c=1.56929e-17
    C335 (net2 \4\:net1) capacitor c=2.34924e-18
    C336 (\8\:I0\|net8 \3\:net5) capacitor c=2.28497e-17
    C337 (\7\:net7 \2\:Y4) capacitor c=7.63119e-18
    C338 (\6\:net8 \5\:S03) capacitor c=9.01224e-19
    C339 (\1\:X1 \7\:S00) capacitor c=3.2667e-18
    C340 (S13 \6\:S03) capacitor c=1.39476e-17
    C341 (\2\:S21 \3\:S11) capacitor c=5.72614e-18
    C342 (\6\:S14 \1\:Y1) capacitor c=3.30763e-17
    C343 (\5\:I0\|N_S12 \6\:net6) capacitor c=8.31734e-18
    C344 (\1\:X7 \3\:I5\|N_S) capacitor c=2.02157e-18
    C345 (\8\:I0\|net1 \6\:net8) capacitor c=5.83366e-17
    C346 (\4\:I0\|N_S10 \1\:S11) capacitor c=1.53247e-17
    C347 (\6\:I2\|N_S \6\:net4) capacitor c=6.5715e-17
    C348 (\6\:I0\|N_S11 \6\:S12) capacitor c=1.32724e-17
    C349 (\146\:gnd! \7\:I1\|N_S10) capacitor c=1.46986e-17
    C350 (\3\:Y3 \3\:S14) capacitor c=1.183e-17
    C351 (\2\:Y0 net8) capacitor c=1.33869e-18
    C352 (\2\:net19 \6\:S34) capacitor c=7.81933e-17
    C353 (\5\:I0\|N_S12 \3\:S03) capacitor c=7.566e-18
    C354 (\6\:I0\|N_S11 \52\:vdd!) capacitor c=3.96145e-17
    C355 (\1\:S13 I0\|N_S12) capacitor c=2.2056e-17
    C356 (\4\:net3 \6\:X0) capacitor c=1.59315e-18
    C357 (\7\:I0\|net3 \2\:net5) capacitor c=1.49578e-16
    C358 (\6\:net2 \7\:S10) capacitor c=1.45011e-18
    C359 (\3\:I1\|net5 \6\:I1\|N_S11) capacitor c=6.03921e-18
    C360 (\6\:I0\|net3 \5\:I0\|net9) capacitor c=4.3015e-17
    C361 (\7\:I8\|N_S \97\:vdd!) capacitor c=3.67281e-17
    C362 (\159\:gnd! \7\:S01) capacitor c=7.95287e-19
    C363 (\8\:I0\|net6 \3\:I0\|N_S11) capacitor c=1.313e-18
    C364 (\4\:net15 \7\:I1\|N_S10) capacitor c=4.92896e-17
    C365 (\7\:I1\|net6 \1\:S32) capacitor c=2.74877e-18
    C366 (\2\:net18 \4\:I2\|N_S) capacitor c=2.06305e-18
    C367 (\4\:I0\|net1 \3\:I0\|N_S01) capacitor c=4.67246e-18
    C368 (\4\:I1\|net2 \7\:S32) capacitor c=3.05462e-18
    C369 (\6\:I1\|net9 \7\:S22) capacitor c=4.94547e-18
    C370 (\6\:I0\|net10 \2\:I0\|net10) capacitor c=3.66333e-18
    C371 (\6\:net19 \5\:S34) capacitor c=4.5157e-18
    C372 (\2\:net7 \6\:net8) capacitor c=1.63141e-17
    C373 (\2\:I0\|net8 net5) capacitor c=3.90356e-18
    C374 (\9\:I1\|N_S12 \4\:S33) capacitor c=4.63329e-18
    C375 (\6\:net4 \2\:X0) capacitor c=6.22382e-17
    C376 (\5\:I1\|N_S00 \1\:S21) capacitor c=1.19557e-17
    C377 (\3\:Y3 \3\:I7\|N_S) capacitor c=3.86434e-18
    C378 (\4\:net15 \9\:I1\|N_S10) capacitor c=3.55027e-17
    C379 (net19 \3\:S34) capacitor c=1.97636e-18
    C380 (\10\:I1\|net8 net20) capacitor c=2.23143e-18
    C381 (\10\:I1\|net10 \62\:vdd!) capacitor c=3.57671e-18
    C382 (\10\:I1\|net6 \8\:I1\|net10) capacitor c=2.17732e-17
    C383 (\8\:net22 \3\:S04) capacitor c=1.50792e-18
    C384 (\10\:I0\|net3 \5\:I0\|N_S12) capacitor c=6.54077e-18
    C385 (\2\:I1\|net8 \3\:S32) capacitor c=1.52688e-17
    C386 (\2\:I1\|net10 \7\:I1\|N_S01) capacitor c=3.08867e-17
    C387 (\1\:X0 S11) capacitor c=4.70743e-18
    C388 (\6\:net22 \1\:Y0) capacitor c=3.79016e-17
    C389 (\5\:net20 \3\:S14) capacitor c=1.83757e-18
    C390 (\2\:net19 \5\:net20) capacitor c=2.35457e-18
    C391 (\6\:X4 \8\:net17) capacitor c=3.12131e-17
    C392 (\3\:net16 vdd!) capacitor c=2.04612e-17
    C393 (\3\:net7 \3\:I0\|N_S02) capacitor c=6.62237e-18
    C394 (\6\:Y3 \5\:I7\|N_S) capacitor c=1.83818e-17
    C395 (\5\:net22 \2\:I6\|N_S) capacitor c=4.00268e-18
    C396 (net17 \3\:I1\|N_S00) capacitor c=1.99781e-18
    C397 (\3\:S04 \3\:I6\|N_S) capacitor c=2.71349e-17
    C398 (I0\|net3 \3\:S02) capacitor c=6.35302e-18
    C399 (\2\:X3 \6\:S10) capacitor c=3.1358e-18
    C400 (\3\:net18 vdd!) capacitor c=2.14533e-17
    C401 (\2\:I0\|net6 \2\:S11) capacitor c=1.55595e-17
    C402 (\2\:I1\|net6 \7\:net16) capacitor c=1.40149e-17
    C403 (\6\:I1\|net8 \112\:gnd!) capacitor c=2.45952e-18
    C404 (\3\:I1\|net6 \2\:I1\|net6) capacitor c=4.40801e-18
    C405 (\2\:I6\|N_S \7\:S04) capacitor c=2.7525e-17
    C406 (\3\:S31 \4\:S32) capacitor c=6.14689e-18
    C407 (\7\:net21 \4\:I1\|N_S02) capacitor c=2.40414e-18
    C408 (\4\:I0\|net5 \3\:I0\|N_S10) capacitor c=4.80509e-18
    C409 (\159\:gnd! \5\:net3) capacitor c=6.89513e-18
    C410 (\1\:Y3 \2\:I7\|N_S) capacitor c=3.59059e-18
    C411 (\4\:net3 X0) capacitor c=8.79301e-19
    C412 (\2\:X1 \7\:S00) capacitor c=4.3345e-19
    C413 (\2\:net4 \3\:I0\|N_S00) capacitor c=1.36365e-17
    C414 (\4\:net3 \2\:net16) capacitor c=6.04735e-17
    C415 (\3\:net18 \4\:net18) capacitor c=2.90049e-18
    C416 (\8\:I0\|net1 \4\:net7) capacitor c=2.93141e-18
    C417 (\6\:net2 \6\:S11) capacitor c=5.49303e-18
    C418 (\1\:S23 I1\|N_S02) capacitor c=2.20261e-17
    C419 (\1\:X0 X0) capacitor c=9.49428e-18
    C420 (\2\:net3 \6\:S20) capacitor c=8.99987e-18
    C421 (\6\:net7 \2\:I8\|N_S) capacitor c=9.84726e-19
    C422 (\8\:net3 \6\:I2\|N_S) capacitor c=8.0196e-18
    C423 (\2\:net1 vdd!) capacitor c=3.51253e-18
    C424 (\8\:net16 \7\:S31) capacitor c=1.37002e-18
    C425 (\5\:I1\|net5 \2\:I1\|net3) capacitor c=7.08283e-17
    C426 (\7\:I0\|net6 \2\:I0\|N_S11) capacitor c=8.73444e-19
    C427 (\5\:X2 \5\:net16) capacitor c=3.2821e-17
    C428 (\4\:net3 vdd!) capacitor c=1.12188e-17
    C429 (I1\|net6 \10\:net16) capacitor c=5.27181e-17
    C430 (\4\:I1\|N_S00 \1\:S21) capacitor c=1.58458e-17
    C431 (\7\:net19 \7\:S33) capacitor c=2.05808e-18
    C432 (\9\:S22 \6\:S23) capacitor c=2.72769e-17
    C433 (\7\:I1\|N_S12 \82\:vdd!) capacitor c=3.92493e-17
    C434 (\2\:X6 \6\:S30) capacitor c=2.00795e-18
    C435 (\2\:S31 \3\:S21) capacitor c=5.72259e-18
    C436 (\5\:vdd! \6\:I2\|N_S) capacitor c=3.75925e-17
    C437 (\7\:I1\|N_S00 \5\:S21) capacitor c=1.593e-17
    C438 (\3\:I0\|net5 \2\:S11) capacitor c=2.57819e-18
    C439 (\2\:net18 \2\:X2) capacitor c=7.50774e-18
    C440 (\1\:S20 \3\:S10) capacitor c=2.03192e-17
    C441 (\9\:net18 \4\:S11) capacitor c=2.3396e-18
    C442 (\6\:I0\|net10 \4\:I0\|net9) capacitor c=2.4098e-18
    C443 (\2\:Y2 \5\:net20) capacitor c=4.63529e-17
    C444 (\4\:net17 \9\:I4\|N_S) capacitor c=4.62707e-17
    C445 (\9\:I3\|N_S \3\:S10) capacitor c=4.87579e-18
    C446 (\5\:I0\|N_S11 \4\:S02) capacitor c=5.9522e-18
    C447 (\3\:I0\|net9 \6\:net3) capacitor c=8.0867e-17
    C448 (\7\:I0\|net3 \10\:I0\|net8) capacitor c=1.78855e-17
    C449 (\3\:net16 \4\:net16) capacitor c=2.85977e-18
    C450 (\8\:I0\|net2 \3\:net7) capacitor c=1.95329e-18
    C451 (\2\:net16 vdd!) capacitor c=6.25087e-18
    C452 (\4\:net3 \6\:X2) capacitor c=8.48882e-19
    C453 (\4\:net1 I0\|N_S10) capacitor c=9.23953e-18
    C454 (\8\:I0\|net5 I0\|net3) capacitor c=1.53738e-17
    C455 (net2 \3\:S11) capacitor c=1.01834e-17
    C456 (\6\:net5 \4\:net20) capacitor c=3.33706e-18
    C457 (\42\:vdd! \5\:S31) capacitor c=6.02704e-18
    C458 (\6\:I0\|net8 \4\:S13) capacitor c=1.49609e-18
    C459 (\2\:net7 \7\:I6\|N_S) capacitor c=3.08435e-17
    C460 (\8\:I1\|net3 \2\:I1\|N_S12) capacitor c=8.31749e-19
    C461 (\3\:I0\|net10 \3\:S01) capacitor c=2.9304e-18
    C462 (\9\:I6\|N_S \4\:S04) capacitor c=4.92116e-18
    C463 (\1\:S33 I1\|N_S12) capacitor c=2.1919e-17
    C464 (\7\:I1\|net8 net20) capacitor c=5.25684e-17
    C465 (\2\:I0\|net6 \8\:I0\|N_S11) capacitor c=2.46393e-17
    C466 (\4\:I1\|net5 net15) capacitor c=3.18651e-17
    C467 (\6\:I0\|net1 \7\:S03) capacitor c=4.98236e-18
    C468 (\159\:gnd! \3\:S01) capacitor c=1.13119e-18
    C469 (\5\:I1\|N_S02 \3\:S13) capacitor c=5.79403e-18
    C470 (\4\:net17 \5\:S21) capacitor c=3.9663e-18
    C471 (\126\:gnd! \4\:S14) capacitor c=8.26258e-18
    C472 (\8\:net22 \13\:net5) capacitor c=1.79496e-17
    C473 (\8\:net6 \7\:S13) capacitor c=3.04758e-18
    C474 (\2\:Y5 I8\|N_S) capacitor c=1.44956e-18
    C475 (\4\:Y4 \10\:S22) capacitor c=3.64582e-18
    C476 (\1\:Y1 \2\:net8) capacitor c=6.53693e-17
    C477 (\6\:I1\|net2 \7\:S23) capacitor c=2.12764e-18
    C478 (\3\:S14 \3\:I7\|N_S) capacitor c=2.71349e-17
    C479 (\5\:I1\|N_S10 \1\:S31) capacitor c=1.19316e-17
    C480 (\108\:vdd! \5\:S04) capacitor c=1.15493e-18
    C481 (\8\:I0\|net6 \3\:I0\|net8) capacitor c=2.34067e-17
    C482 (\5\:net22 \4\:Y1) capacitor c=3.50703e-17
    C483 (\7\:net1 \9\:I0\|N_S10) capacitor c=3.5383e-18
    C484 (\2\:I7\|N_S \7\:S14) capacitor c=2.7525e-17
    C485 (\4\:net3 \4\:I2\|N_S) capacitor c=8.34955e-19
    C486 (\7\:net16 \2\:net1) capacitor c=6.49289e-18
    C487 (\87\:vdd! \5\:S04) capacitor c=6.31164e-18
    C488 (\10\:net5 \7\:net7) capacitor c=1.65494e-17
    C489 (\2\:I0\|net6 \4\:S12) capacitor c=7.48879e-18
    C490 (\2\:Y3 \5\:Y3) capacitor c=2.02943e-18
    C491 (\4\:I1\|N_S10 \1\:S31) capacitor c=1.53225e-17
    C492 (S20 \5\:I4\|N_S) capacitor c=9.75178e-19
    C493 (\8\:net22 \1\:Y1) capacitor c=2.52694e-18
    C494 (\6\:I1\|net3 \9\:I1\|N_S02) capacitor c=1.58944e-18
    C495 (\108\:vdd! \4\:net7) capacitor c=7.98775e-18
    C496 (\3\:I1\|net2 \7\:I1\|net6) capacitor c=7.58696e-17
    C497 (\111\:vdd! \5\:I1\|net2) capacitor c=7.13112e-18
    C498 (\159\:gnd! net4) capacitor c=8.48781e-18
    C499 (\2\:net16 \7\:S10) capacitor c=2.03173e-18
    C500 (\6\:I0\|N_S11 \4\:S02) capacitor c=4.20613e-18
    C501 (\7\:net1 \2\:net17) capacitor c=2.56037e-18
    C502 (\3\:S01 \2\:I0\|N_S00) capacitor c=5.2245e-17
    C503 (\6\:S10 \4\:S00) capacitor c=5.20353e-18
    C504 (\6\:S31 \4\:net17) capacitor c=9.67581e-17
    C505 (\4\:net17 \5\:X4) capacitor c=7.28408e-17
    C506 (\10\:I1\|net3 \5\:I1\|net2) capacitor c=1.53376e-18
    C507 (\4\:I0\|N_S02 \1\:S03) capacitor c=1.57496e-17
    C508 (\7\:net1 \3\:S10) capacitor c=1.9682e-18
    C509 (\6\:I0\|net10 \4\:net2) capacitor c=1.36605e-17
    C510 (\6\:net22 vdd!) capacitor c=5.59145e-18
    C511 (\2\:I0\|net6 \2\:I0\|net10) capacitor c=4.57434e-18
    C512 (\8\:I1\|net9 \7\:I1\|N_S01) capacitor c=1.25649e-18
    C513 (X6 \4\:S30) capacitor c=1.06112e-18
    C514 (\3\:net18 \6\:X0) capacitor c=6.27368e-17
    C515 (\2\:I0\|net8 \2\:S12) capacitor c=1.30863e-17
    C516 (\8\:I0\|net10 \3\:I0\|net2) capacitor c=9.0003e-18
    C517 (\5\:net20 vdd!) capacitor c=4.7345e-18
    C518 (\8\:I1\|net1 \5\:I1\|N_S02) capacitor c=8.80696e-18
    C519 (\3\:I0\|net1 \2\:S02) capacitor c=1.59221e-18
    C520 (\148\:gnd! \4\:I1\|net9) capacitor c=6.90094e-18
    C521 (\2\:net21 vdd!) capacitor c=7.90323e-18
    C522 (I0\|net6 \7\:S11) capacitor c=2.02461e-18
    C523 (\5\:X0 \6\:X0) capacitor c=3.18802e-18
    C524 (\3\:I1\|net6 \6\:net16) capacitor c=1.91105e-17
    C525 (\2\:I1\|net8 \8\:I1\|net10) capacitor c=6.0401e-18
    C526 (\148\:gnd! I1\|net10) capacitor c=1.34556e-17
    C527 (\7\:net19 \4\:I1\|N_S12) capacitor c=2.42889e-18
    C528 (\2\:net19 vdd!) capacitor c=5.40105e-18
    C529 (\109\:vdd! \8\:I0\|net1) capacitor c=1.94012e-17
    C530 (\4\:net6 \6\:S14) capacitor c=1.46759e-16
    C531 (\10\:I0\|net3 \6\:net6) capacitor c=6.88109e-17
    C532 (\7\:I1\|N_S01 \6\:S22) capacitor c=1.33253e-17
    C533 (\8\:I0\|net2 net7) capacitor c=1.50764e-17
    C534 (net5 \3\:I0\|N_S12) capacitor c=6.86291e-18
    C535 (\6\:net19 \8\:I1\|net3) capacitor c=5.89416e-18
    C536 (\4\:Y0 \1\:Y1) capacitor c=1.28237e-18
    C537 (\6\:I0\|net10 \2\:I0\|net6) capacitor c=4.71245e-18
    C538 (\6\:net5 \4\:S14) capacitor c=2.18799e-18
    C539 (\5\:X0 \4\:I2\|N_S) capacitor c=6.58472e-18
    C540 (\3\:net18 \4\:S00) capacitor c=6.15072e-18
    C541 (\4\:Y5 \5\:I8\|N_S) capacitor c=1.96779e-17
    C542 (\4\:net17 \6\:I4\|N_S) capacitor c=6.2295e-17
    C543 (\2\:net3 \7\:S20) capacitor c=1.64543e-18
    C544 (\3\:Y0 \2\:I6\|N_S) capacitor c=1.01223e-18
    C545 (I0\|net8 \3\:S12) capacitor c=7.03248e-18
    C546 (\3\:X6 \7\:S30) capacitor c=4.84728e-18
    C547 (\3\:S24 \3\:I8\|N_S) capacitor c=2.71349e-17
    C548 (\3\:net7 \5\:S03) capacitor c=1.41627e-18
    C549 (\4\:I0\|N_S12 \1\:S13) capacitor c=1.52837e-17
    C550 (\148\:gnd! \2\:I1\|net10) capacitor c=1.37504e-17
    C551 (\2\:X5 \6\:S20) capacitor c=3.5581e-18
    C552 (\5\:I1\|N_S01 \4\:S12) capacitor c=5.27672e-18
    C553 (\3\:Y1 \8\:net22) capacitor c=6.40367e-18
    C554 (net3 \7\:S20) capacitor c=3.20944e-18
    C555 (\2\:I8\|N_S \7\:S24) capacitor c=2.75246e-17
    C556 (\4\:net20 \2\:I7\|N_S) capacitor c=3.98845e-18
    C557 (\6\:I1\|net5 \3\:I1\|N_S01) capacitor c=1.313e-18
    C558 (\4\:net8 vdd!) capacitor c=5.02314e-18
    C559 (\1\:S30 \3\:S20) capacitor c=2.19313e-17
    C560 (\7\:I9\|N_S \102\:vdd!) capacitor c=3.93714e-17
    C561 (\5\:I0\|net9 \3\:S02) capacitor c=9.36143e-18
    C562 (\5\:X6 \1\:X7) capacitor c=2.49417e-17
    C563 (\4\:I0\|net2 \3\:I0\|N_S11) capacitor c=4.90316e-18
    C564 (\2\:net1 \2\:X2) capacitor c=4.42668e-18
    C565 (\6\:I0\|net9 \3\:I0\|N_S01) capacitor c=1.36035e-17
    C566 (\5\:I1\|N_S12 \3\:S23) capacitor c=7.566e-18
    C567 (X2 \4\:S10) capacitor c=2.24337e-18
    C568 (\8\:I1\|net10 \7\:S32) capacitor c=5.0778e-18
    C569 (\109\:vdd! \4\:net7) capacitor c=1.59027e-17
    C570 (net5 \8\:I0\|net3) capacitor c=1.61126e-16
    C571 (\1\:X3 \7\:S10) capacitor c=3.2667e-18
    C572 (\4\:net6 vdd!) capacitor c=3.905e-18
    C573 (S13 \7\:I0\|N_S02) capacitor c=1.03547e-16
    C574 (\1\:Y5 \2\:I8\|N_S) capacitor c=3.60882e-18
    C575 (S12 \9\:I0\|N_S01) capacitor c=2.6102e-18
    C576 (\7\:I6\|N_S \5\:S04) capacitor c=1.72368e-17
    C577 (\5\:I1\|net5 \2\:I1\|N_S01) capacitor c=8.73444e-19
    C578 (\1\:Y1 \3\:S04) capacitor c=1.54243e-17
    C579 (\5\:net20 \1\:Y2) capacitor c=3.7923e-17
    C580 (\6\:net6 \2\:net7) capacitor c=2.76284e-17
    C581 (\5\:net18 \7\:S00) capacitor c=1.26683e-18
    C582 (\3\:I2\|N_S \7\:S00) capacitor c=2.74181e-17
    C583 (\6\:I1\|net3 \4\:S23) capacitor c=3.43079e-18
    C584 (net17 \6\:I1\|net10) capacitor c=1.79398e-17
    C585 (\7\:net5 \2\:I9\|N_S) capacitor c=8.31939e-18
    C586 (\3\:I1\|net1 \9\:S22) capacitor c=3.16411e-17
    C587 (\10\:I1\|net3 \7\:I1\|net8) capacitor c=6.59686e-18
    C588 (\2\:I0\|net8 \2\:I0\|N_S11) capacitor c=3.44659e-18
    C589 (\4\:net15 \3\:I1\|N_S10) capacitor c=1.31553e-18
    C590 (\6\:I0\|net8 \7\:I0\|net10) capacitor c=4.18114e-17
    C591 (\7\:I1\|N_S01 \57\:vdd!) capacitor c=3.70951e-17
    C592 (\7\:net16 \6\:I1\|net6) capacitor c=2.74396e-18
    C593 (\2\:Y1 vdd!) capacitor c=3.21552e-18
    C594 (\8\:net7 \3\:Y4) capacitor c=4.66546e-17
    C595 (\2\:X3 \7\:S10) capacitor c=4.3345e-19
    C596 (\5\:X2 \2\:net16) capacitor c=1.48598e-16
    C597 (\6\:net4 \5\:I2\|N_S) capacitor c=2.56648e-18
    C598 (\6\:I1\|net9 \4\:I1\|net1) capacitor c=5.17378e-17
    C599 (\146\:gnd! I1\|net6) capacitor c=2.13987e-18
    C600 (\7\:I1\|N_S10 \5\:S31) capacitor c=1.56063e-17
    C601 (\6\:Y3 vdd!) capacitor c=4.43442e-18
    C602 (\5\:X4 \5\:net17) capacitor c=3.28141e-17
    C603 (\9\:I2\|N_S \21\:vdd!) capacitor c=3.30145e-17
    C604 (\6\:net8 \6\:S03) capacitor c=1.51929e-18
    C605 (\6\:S33 \5\:S33) capacitor c=2.07535e-18
    C606 (\5\:net15 \1\:X7) capacitor c=7.78546e-19
    C607 (\6\:S20 \4\:S10) capacitor c=5.25157e-18
    C608 (\22\:vdd! \6\:S11) capacitor c=7.99104e-17
    C609 (\8\:net3 I0\|N_S00) capacitor c=1.08909e-18
    C610 (net15 \3\:I1\|N_S10) capacitor c=1.96474e-18
    C611 (\2\:net17 I1\|N_S00) capacitor c=1.15868e-17
    C612 (\4\:Y5 vdd!) capacitor c=3.1004e-18
    C613 (\10\:I1\|net10 \6\:S32) capacitor c=3.20427e-18
    C614 (\4\:net3 \2\:X0) capacitor c=1.29265e-18
    C615 (\1\:X7 net1) capacitor c=3.38387e-17
    C616 (\6\:I3\|N_S \6\:net2) capacitor c=7.4665e-17
    C617 (\92\:vdd! \5\:S14) capacitor c=6.35716e-18
    C618 (\3\:S11 \2\:I0\|N_S10) capacitor c=5.24677e-17
    C619 (\4\:I1\|N_S02 \1\:S23) capacitor c=1.57496e-17
    C620 (\7\:net20 \4\:S34) capacitor c=3.07792e-17
    C621 (\8\:I1\|net3 \3\:net20) capacitor c=3.89365e-17
    C622 (\3\:I1\|net5 \148\:gnd!) capacitor c=1.56398e-18
    C623 (\4\:I1\|net9 \3\:I1\|N_S00) capacitor c=4.87284e-18
    C624 (\4\:Y7 vdd!) capacitor c=4.44313e-18
    C625 (\2\:Y4 \2\:net21) capacitor c=4.85269e-17
    C626 (\4\:Y0 \3\:Y1) capacitor c=2.08694e-17
    C627 (\6\:net18 \2\:net17) capacitor c=2.1913e-18
    C628 (\6\:Y7 \7\:net20) capacitor c=4.81676e-17
    C629 (\140\:gnd! \4\:net20) capacitor c=3.94588e-18
    C630 (\3\:Y1 \3\:S04) capacitor c=4.09632e-18
    C631 (\6\:I1\|net8 \2\:I1\|net8) capacitor c=5.83309e-18
    C632 (\2\:net2 \3\:I0\|N_S10) capacitor c=1.43729e-17
    C633 (\3\:X4 \2\:net3) capacitor c=6.38074e-18
    C634 (\6\:I1\|net2 \8\:net21) capacitor c=2.33704e-17
    C635 (\7\:net1 \6\:I3\|N_S) capacitor c=1.1267e-18
    C636 (\1\:Y1 \3\:I6\|N_S) capacitor c=3.86228e-18
    C637 (\8\:I1\|N_S11 \84\:gnd!) capacitor c=2.07896e-17
    C638 (\6\:I0\|N_S11 \63\:gnd!) capacitor c=1.13327e-18
    C639 (\4\:net17 \7\:S20) capacitor c=2.03496e-18
    C640 (\6\:net2 \2\:X2) capacitor c=5.8189e-17
    C641 (\9\:I0\|N_S00 I0\|net10) capacitor c=1.85966e-18
    C642 (\3\:I0\|net2 \2\:S12) capacitor c=2.1703e-18
    C643 (\10\:I0\|net8 net5) capacitor c=5.37262e-18
    C644 (\2\:S04 vdd!) capacitor c=1.135e-17
    C645 (\9\:I7\|N_S \4\:S14) capacitor c=4.87416e-18
    C646 (\148\:gnd! \3\:I1\|net10) capacitor c=6.16691e-18
    C647 (\3\:S34 \3\:I9\|N_S) capacitor c=2.71196e-17
    C648 (\6\:S23 \3\:S13) capacitor c=1.38503e-17
    C649 (\8\:I0\|net8 \6\:net5) capacitor c=6.99763e-18
    C650 (\2\:net16 \1\:X5) capacitor c=3.18646e-18
    C651 (\2\:S14 vdd!) capacitor c=1.04631e-17
    C652 (\2\:Y7 I9\|N_S) capacitor c=1.48022e-18
    C653 (\2\:I1\|net10 \2\:S21) capacitor c=1.28359e-17
    C654 (\2\:I9\|N_S \7\:S34) capacitor c=2.7525e-17
    C655 (\10\:I0\|net6 I0\|net8) capacitor c=6.32542e-18
    C656 (\137\:gnd! \4\:S24) capacitor c=7.51132e-18
    C657 (\159\:gnd! \3\:I0\|net9) capacitor c=2.02018e-18
    C658 (\6\:I0\|net3 \3\:S02) capacitor c=5.54342e-18
    C659 (\2\:S24 vdd!) capacitor c=1.16088e-17
    C660 (\8\:I0\|net3 \7\:S13) capacitor c=5.11838e-18
    C661 (\3\:I0\|net5 \4\:net1) capacitor c=7.34269e-17
    C662 (\6\:S12 \4\:S02) capacitor c=1.9794e-17
    C663 (\3\:net18 \5\:I2\|N_S) capacitor c=1.66578e-18
    C664 (net22 \7\:S23) capacitor c=3.15905e-18
    C665 (\3\:net16 \4\:S10) capacitor c=4.20131e-18
    C666 (\2\:S34 vdd!) capacitor c=1.16909e-17
    C667 (\8\:I1\|net8 \7\:S33) capacitor c=2.10827e-18
    C668 (\4\:I1\|N_S12 \1\:S33) capacitor c=1.52399e-17
    C669 (\2\:net1 \2\:X4) capacitor c=5.09449e-18
    C670 (\6\:net18 \3\:S21) capacitor c=9.4595e-18
    C671 (\6\:I0\|net2 \3\:I0\|N_S02) capacitor c=1.313e-18
    C672 (\109\:vdd! \108\:vdd!) capacitor c=1.07739e-17
    C673 (\10\:I1\|net3 \5\:I1\|N_S12) capacitor c=7.12732e-18
    C674 (\7\:net7 \1\:Y5) capacitor c=2.26097e-17
    C675 (\6\:net21 \6\:S23) capacitor c=6.18779e-17
    C676 (\3\:I0\|net6 \3\:S11) capacitor c=2.91346e-18
    C677 (I6\|N_S vdd!) capacitor c=5.42071e-18
    C678 (\9\:I4\|N_S \3\:S20) capacitor c=4.66147e-18
    C679 (\8\:I1\|net2 \5\:I1\|net1) capacitor c=1.51335e-17
    C680 (\8\:net3 S12) capacitor c=1.14781e-17
    C681 (\5\:net3 \3\:S01) capacitor c=1.51042e-18
    C682 (\3\:S02 \4\:S03) capacitor c=6.14689e-18
    C683 (\3\:I0\|net9 I0\|N_S00) capacitor c=2.12521e-18
    C684 (\7\:I1\|N_S01 \4\:S12) capacitor c=2.41413e-18
    C685 (I7\|N_S vdd!) capacitor c=5.15294e-18
    C686 (\9\:S22 \6\:net5) capacitor c=5.29048e-18
    C687 (\4\:Y0 \8\:net22) capacitor c=2.0774e-17
    C688 (\7\:net16 \4\:S31) capacitor c=6.90606e-18
    C689 (\3\:I1\|net5 \2\:S31) capacitor c=1.34412e-18
    C690 (I8\|N_S vdd!) capacitor c=6.56279e-18
    C691 (\5\:I1\|N_S11 \4\:S22) capacitor c=5.9522e-18
    C692 (\10\:S22 \13\:net5) capacitor c=9.66196e-18
    C693 (\5\:X4 \8\:net17) capacitor c=2.14676e-17
    C694 (\5\:I1\|net2 \6\:S23) capacitor c=5.06303e-18
    C695 (\9\:net18 \7\:net1) capacitor c=7.32851e-17
    C696 (\5\:I8\|N_S \6\:net21) capacitor c=2.27279e-17
    C697 (\1\:S11 \3\:S01) capacitor c=7.08454e-18
    C698 (\2\:net5 \6\:net6) capacitor c=1.63541e-17
    C699 (\3\:net7 \5\:I0\|N_S02) capacitor c=2.15393e-17
    C700 (\10\:vdd! \6\:I3\|N_S) capacitor c=3.87159e-17
    C701 (I9\|N_S vdd!) capacitor c=6.65993e-18
    C702 (\5\:X6 X7) capacitor c=1.19477e-18
    C703 (S14 \1\:Y1) capacitor c=5.89876e-17
    C704 (\2\:net16 \5\:X4) capacitor c=2.32094e-17
    C705 (\9\:S22 \4\:S12) capacitor c=7.51234e-18
    C706 (\8\:I0\|net5 \6\:I0\|net3) capacitor c=5.15866e-17
    C707 (net5 \5\:S13) capacitor c=1.42725e-18
    C708 (\4\:Y6 \2\:Y7) capacitor c=1.16183e-17
    C709 (\1\:X6 X7) capacitor c=2.32799e-18
    C710 (\1\:S04 vdd!) capacitor c=5.90183e-18
    C711 (\2\:Y5 \3\:S24) capacitor c=3.69602e-18
    C712 (\7\:net21 \3\:I1\|N_S02) capacitor c=6.62237e-18
    C713 (\10\:I0\|net3 \6\:S13) capacitor c=1.45163e-18
    C714 (\5\:X2 \4\:I3\|N_S) capacitor c=6.52715e-18
    C715 (\3\:I3\|N_S \7\:S10) capacitor c=2.74179e-17
    C716 (\7\:I1\|net8 \6\:net19) capacitor c=7.16476e-17
    C717 (\1\:S14 vdd!) capacitor c=6.19209e-18
    C718 (\7\:I6\|N_S vdd!) capacitor c=3.01003e-18
    C719 (\7\:I7\|N_S \5\:S14) capacitor c=1.71886e-17
    C720 (\6\:S30 \4\:S20) capacitor c=5.21095e-18
    C721 (\2\:I0\|net8 \9\:I0\|N_S12) capacitor c=2.49258e-17
    C722 (net18 I2\|N_S) capacitor c=1.98241e-17
    C723 (\1\:S24 vdd!) capacitor c=5.60833e-18
    C724 (\7\:I7\|N_S vdd!) capacitor c=3.77608e-18
    C725 (\4\:Y7 \5\:I9\|N_S) capacitor c=2.13559e-17
    C726 (\3\:I1\|net8 \2\:I1\|net8) capacitor c=5.07505e-18
    C727 (\1\:S34 vdd!) capacitor c=5.97754e-18
    C728 (\7\:I8\|N_S vdd!) capacitor c=2.33474e-18
    C729 (\6\:I1\|net8 \4\:S33) capacitor c=2.41334e-18
    C730 (\4\:net2 I0\|N_S10) capacitor c=1.52917e-18
    C731 (\10\:I1\|net10 \6\:I1\|N_S11) capacitor c=5.63948e-18
    C732 (\2\:net8 \2\:I6\|N_S) capacitor c=9.46579e-19
    C733 (I1\|net3 \3\:S22) capacitor c=6.35302e-18
    C734 (\3\:S21 \2\:I1\|N_S00) capacitor c=5.2245e-17
    C735 (\2\:I0\|net6 \5\:I0\|net6) capacitor c=2.21821e-18
    C736 (net4 \2\:I0\|net10) capacitor c=1.49241e-16
    C737 (\8\:I1\|net1 \2\:net22) capacitor c=5.8007e-17
    C738 (\4\:I6\|N_S vdd!) capacitor c=9.30237e-18
    C739 (\8\:I1\|net1 \4\:net22) capacitor c=3.0194e-18
    C740 (\6\:S32 \6\:I1\|N_S11) capacitor c=9.04999e-17
    C741 (\6\:S23 \98\:gnd!) capacitor c=2.44072e-18
    C742 (\2\:net7 I0\|N_S02) capacitor c=1.47765e-18
    C743 (\10\:I0\|net3 \8\:I0\|net2) capacitor c=1.78367e-16
    C744 (X0 \3\:net18) capacitor c=9.86917e-18
    C745 (\5\:net17 \2\:X5) capacitor c=1.06027e-16
    C746 (\134\:gnd! \3\:Y5) capacitor c=2.58013e-18
    C747 (\6\:I1\|net8 \9\:I1\|N_S12) capacitor c=4.70323e-18
    C748 (\9\:I0\|N_S00 \35\:gnd!) capacitor c=2.07334e-17
    C749 (\6\:X6 \8\:net15) capacitor c=3.12131e-17
    C750 (\4\:I7\|N_S vdd!) capacitor c=8.47498e-18
    C751 (\3\:Y2 \2\:I7\|N_S) capacitor c=9.81556e-19
    C752 (\146\:gnd! \4\:net15) capacitor c=1.09033e-17
    C753 (\10\:net5 \5\:net20) capacitor c=1.2826e-17
    C754 (\6\:net4 \1\:S00) capacitor c=4.66233e-17
    C755 (\2\:X7 \6\:S30) capacitor c=4.44071e-18
    C756 (\6\:I0\|net6 \2\:I0\|net6) capacitor c=4.10204e-18
    C757 (\3\:I6\|N_S \7\:S04) capacitor c=2.72912e-17
    C758 (\4\:I8\|N_S vdd!) capacitor c=6.81505e-18
    C759 (\3\:Y5 \3\:S24) capacitor c=1.32352e-17
    C760 (\97\:vdd! \5\:S24) capacitor c=6.22788e-18
    C761 (\2\:net16 \1\:X7) capacitor c=5.28922e-19
    C762 (\7\:net16 X6) capacitor c=1.6074e-18
    C763 (\2\:net18 \4\:S00) capacitor c=1.17498e-17
    C764 (\7\:I1\|net6 \2\:I1\|N_S11) capacitor c=8.73444e-19
    C765 (\4\:I9\|N_S vdd!) capacitor c=7.78634e-18
    C766 (\7\:net16 \2\:X6) capacitor c=1.90704e-18
    C767 (net21 \2\:I8\|N_S) capacitor c=4.0068e-18
    C768 (\10\:S22 \6\:S23) capacitor c=7.86876e-18
    C769 (\7\:net5 net19) capacitor c=1.29254e-17
    C770 (\5\:S04 vdd!) capacitor c=9.16807e-18
    C771 (I0\|net3 \4\:I0\|N_S01) capacitor c=2.40414e-18
    C772 (\4\:net20 \1\:Y3) capacitor c=3.27935e-17
    C773 (\2\:X1 \5\:I2\|N_S) capacitor c=1.15072e-17
    C774 (\6\:I1\|net9 \3\:I1\|net1) capacitor c=8.99847e-18
    C775 (\1\:Y7 \2\:I9\|N_S) capacitor c=3.59315e-18
    C776 (\5\:S14 vdd!) capacitor c=1.05084e-17
    C777 (\5\:I0\|net2 vdd!) capacitor c=3.58152e-18
    C778 (\2\:net1 \2\:X6) capacitor c=5.61977e-17
    C779 (net6 \2\:Y3) capacitor c=2.57452e-17
    C780 (\2\:net15 I1\|N_S10) capacitor c=1.02249e-17
    C781 (\4\:net15 \5\:S31) capacitor c=1.59138e-18
    C782 (\6\:I2\|N_S \2\:S00) capacitor c=1.64676e-17
    C783 (\148\:gnd! \9\:I1\|N_S01) capacitor c=1.89471e-18
    C784 (\2\:net7 \6\:I0\|net1) capacitor c=5.64078e-18
    C785 (\5\:S24 vdd!) capacitor c=9.34289e-18
    C786 (\4\:Y1 \7\:S04) capacitor c=1.3739e-18
    C787 (\7\:I0\|net8 vdd!) capacitor c=1.70514e-18
    C788 (\4\:net22 \9\:S22) capacitor c=2.2633e-17
    C789 (\3\:I0\|net3 \3\:S02) capacitor c=2.9304e-18
    C790 (\4\:Y2 \2\:Y3) capacitor c=8.95661e-18
    C791 (\6\:net5 \3\:Y2) capacitor c=3.46596e-18
    C792 (\22\:vdd! \9\:I2\|N_S) capacitor c=9.59588e-18
    C793 (\3\:Y5 \3\:I8\|N_S) capacitor c=3.86224e-18
    C794 (\3\:S12 \4\:S13) capacitor c=6.63161e-18
    C795 (\6\:net2 \5\:I3\|N_S) capacitor c=2.70713e-18
    C796 (\6\:S13 \9\:I0\|N_S02) capacitor c=6.10929e-17
    C797 (\4\:Y6 \3\:Y7) capacitor c=1.57218e-18
    C798 (S13 \9\:I0\|N_S02) capacitor c=4.06031e-18
    C799 (\7\:I0\|net10 \3\:S12) capacitor c=9.20445e-18
    C800 (\2\:net5 \7\:I7\|N_S) capacitor c=3.26457e-17
    C801 (\5\:S34 vdd!) capacitor c=1.00027e-17
    C802 (\8\:I1\|net6 \3\:I1\|N_S11) capacitor c=1.30705e-18
    C803 (\5\:I1\|net2 vdd!) capacitor c=3.28283e-18
    C804 (\9\:S22 \5\:I1\|N_S01) capacitor c=6.53813e-18
    C805 (\4\:net8 \6\:net22) capacitor c=7.60648e-18
    C806 (\1\:S21 \3\:S11) capacitor c=5.45127e-18
    C807 (\6\:net6 \6\:S13) capacitor c=1.37881e-18
    C808 (\2\:Y4 \6\:net7) capacitor c=2.37728e-18
    C809 (\5\:net20 \2\:I7\|N_S) capacitor c=8.03047e-19
    C810 (\1\:Y4 \2\:net21) capacitor c=4.73102e-17
    C811 (\6\:S22 \4\:S12) capacitor c=1.82821e-17
    C812 (\4\:I1\|net1 \3\:I1\|N_S01) capacitor c=4.67246e-18
    C813 (\6\:I0\|net10 I0\|net10) capacitor c=5.69631e-18
    C814 (\2\:I1\|net3 \2\:S22) capacitor c=1.28338e-17
    C815 (\2\:S03 vdd!) capacitor c=5.58888e-18
    C816 (\8\:I0\|net10 \3\:I0\|N_S11) capacitor c=1.33822e-17
    C817 (\7\:I1\|net8 vdd!) capacitor c=2.12374e-18
    C818 (\7\:net18 net17) capacitor c=1.23924e-17
    C819 (\10\:I1\|net3 \6\:net21) capacitor c=3.96242e-18
    C820 (\6\:net3 \1\:S01) capacitor c=2.86622e-18
    C821 (\6\:I1\|net5 \3\:I1\|net3) capacitor c=2.34074e-17
    C822 (\2\:net4 \4\:I0\|net9) capacitor c=5.25119e-17
    C823 (\2\:I0\|net8 \3\:I0\|N_S12) capacitor c=1.16238e-18
    C824 (\2\:S13 vdd!) capacitor c=7.16233e-18
    C825 (\6\:I0\|net8 \3\:S12) capacitor c=2.97719e-18
    C826 (\8\:net4 \4\:I2\|N_S) capacitor c=1.26358e-18
    C827 (\6\:net8 vdd!) capacitor c=6.18935e-18
    C828 (\2\:I1\|net10 \4\:S22) capacitor c=7.65431e-18
    C829 (\2\:Y6 \2\:net19) capacitor c=1.74252e-17
    C830 (\2\:I1\|net3 \7\:net21) capacitor c=3.90356e-18
    C831 (\6\:net21 \9\:I8\|N_S) capacitor c=2.62951e-17
    C832 (\2\:S23 vdd!) capacitor c=6.10272e-18
    C833 (\6\:net6 vdd!) capacitor c=3.61364e-18
    C834 (\6\:I0\|net10 \2\:net4) capacitor c=3.21271e-18
    C835 (\6\:I1\|net3 \6\:net19) capacitor c=2.21552e-18
    C836 (\2\:Y6 \10\:net5) capacitor c=2.54612e-17
    C837 (\3\:I0\|net5 I0\|N_S10) capacitor c=2.41574e-18
    C838 (\3\:net16 \5\:I3\|N_S) capacitor c=1.66578e-18
    C839 (net1 \7\:S30) capacitor c=3.14453e-18
    C840 (\5\:X2 \6\:X2) capacitor c=1.6005e-18
    C841 (\4\:net3 \2\:X4) capacitor c=4.10818e-18
    C842 (\2\:S33 vdd!) capacitor c=6.64821e-18
    C843 (\2\:net22 vdd!) capacitor c=4.76663e-18
    C844 (S31 \4\:net17) capacitor c=6.38016e-17
    C845 (\4\:net7 S04) capacitor c=1.20083e-18
    C846 (S31 \5\:net17) capacitor c=1.40763e-17
    C847 (\5\:X0 X1) capacitor c=1.85185e-18
    C848 (\1\:X5 \7\:S20) capacitor c=3.31574e-18
    C849 (I0\|N_S02 vdd!) capacitor c=6.18607e-18
    C850 (\4\:net7 \2\:S03) capacitor c=9.47569e-19
    C851 (\6\:net21 \4\:S24) capacitor c=7.66934e-18
    C852 (\10\:I0\|net3 \2\:net7) capacitor c=2.90728e-18
    C853 (I0\|N_S12 vdd!) capacitor c=5.72872e-18
    C854 (\7\:Y7 Y6) capacitor c=7.76659e-18
    C855 (\3\:net7 \4\:S03) capacitor c=6.27211e-18
    C856 (I1\|N_S02 vdd!) capacitor c=5.46306e-18
    C857 (\4\:net17 vdd!) capacitor c=7.79136e-18
    C858 (\3\:I4\|N_S \7\:S20) capacitor c=2.74179e-17
    C859 (X4 \4\:S20) capacitor c=1.07408e-18
    C860 (\3\:I7\|N_S \7\:S14) capacitor c=2.74806e-17
    C861 (\7\:net16 \3\:X6) capacitor c=1.1581e-17
    C862 (\5\:I0\|net9 \5\:I0\|net5) capacitor c=2.38475e-18
    C863 (\8\:I1\|net2 \7\:net21) capacitor c=1.95329e-18
    C864 (I1\|N_S12 vdd!) capacitor c=4.77857e-18
    C865 (\6\:I1\|net3 \5\:I1\|net9) capacitor c=4.3015e-17
    C866 (\5\:net17 vdd!) capacitor c=2.01504e-17
    C867 (\7\:net21 \6\:I1\|net1) capacitor c=1.63619e-16
    C868 (\9\:I8\|N_S \4\:S24) capacitor c=4.92116e-18
    C869 (\3\:S31 \2\:I1\|N_S10) capacitor c=5.25445e-17
    C870 (\6\:I1\|N_S11 \62\:vdd!) capacitor c=3.94555e-17
    C871 (\7\:I8\|N_S \5\:S24) capacitor c=1.66601e-17
    C872 (\1\:S03 vdd!) capacitor c=7.12458e-18
    C873 (\4\:I1\|net5 \3\:I1\|N_S10) capacitor c=4.60003e-18
    C874 (\2\:Y7 \3\:S34) capacitor c=3.71746e-18
    C875 (net15 \6\:I1\|net6) capacitor c=1.55986e-17
    C876 (\7\:net1 \9\:I3\|N_S) capacitor c=4.03805e-18
    C877 (\133\:gnd! \4\:S34) capacitor c=9.38504e-18
    C878 (\1\:S13 vdd!) capacitor c=6.8968e-18
    C879 (\7\:net18 \3\:I1\|N_S00) capacitor c=1.3827e-17
    C880 (\4\:net15 vdd!) capacitor c=8.5375e-18
    C881 (I0\|net10 \3\:I0\|N_S00) capacitor c=6.22606e-18
    C882 (\7\:I1\|net6 \2\:I1\|net8) capacitor c=7.18899e-17
    C883 (\8\:I1\|net1 \6\:S23) capacitor c=7.53002e-18
    C884 (\2\:S00 \5\:S01) capacitor c=3.17741e-18
    C885 (\4\:net17 \3\:X4) capacitor c=1.35693e-16
    C886 (\1\:S23 vdd!) capacitor c=7.16661e-18
    C887 (\6\:I1\|N_S11 \4\:S22) capacitor c=4.20613e-18
    C888 (\6\:net18 net17) capacitor c=1.22449e-17
    C889 (\5\:net15 vdd!) capacitor c=2.05199e-17
    C890 (\6\:I1\|net1 \7\:S23) capacitor c=4.98236e-18
    C891 (\5\:net3 \3\:I0\|net10) capacitor c=2.34103e-17
    C892 (\8\:I0\|net5 \3\:S02) capacitor c=1.82472e-18
    C893 (net7 \2\:net7) capacitor c=4.37745e-18
    C894 (\8\:I1\|net5 I1\|net3) capacitor c=1.53738e-17
    C895 (\4\:Y6 \7\:net20) capacitor c=6.99066e-17
    C896 (\1\:S33 vdd!) capacitor c=5.41981e-18
    C897 (\7\:S33 \3\:net20) capacitor c=1.84862e-18
    C898 (\7\:net21 vdd!) capacitor c=1.05049e-17
    C899 (\7\:net19 \3\:I1\|N_S12) capacitor c=7.0693e-18
    C900 (\3\:X0 \8\:net4) capacitor c=5.32888e-17
    C901 (\8\:net8 \3\:I0\|N_S02) capacitor c=4.96483e-18
    C902 (\5\:X4 \4\:I4\|N_S) capacitor c=6.50483e-18
    C903 (\10\:net5 Y6) capacitor c=1.5613e-17
    C904 (\111\:vdd! \7\:I9\|N_S) capacitor c=1.9976e-18
    C905 (\10\:I0\|net6 \6\:I0\|net8) capacitor c=2.48313e-17
    C906 (\8\:I0\|net8 \3\:I0\|N_S12) capacitor c=1.40137e-18
    C907 (\6\:net5 \3\:S13) capacitor c=2.86022e-18
    C908 (\10\:I0\|net3 \109\:vdd!) capacitor c=1.40221e-16
    C909 (\4\:I0\|N_S02 vdd!) capacitor c=6.94961e-18
    C910 (net5 \5\:I0\|N_S12) capacitor c=2.30557e-17
    C911 (\3\:I0\|net1 I0\|N_S01) capacitor c=2.28328e-18
    C912 (\10\:I0\|net10 \2\:I0\|net6) capacitor c=8.166e-18
    C913 (\7\:net19 vdd!) capacitor c=2.38321e-18
    C914 (\3\:I1\|net2 \2\:S32) capacitor c=2.20715e-18
    C915 (\1\:S31 \3\:S21) capacitor c=5.45127e-18
    C916 (\2\:X4 \1\:S20) capacitor c=6.22163e-18
    C917 (\1\:X0 X1) capacitor c=3.36724e-18
    C918 (\102\:vdd! \5\:S34) capacitor c=6.35716e-18
    C919 (\6\:S33 \2\:S32) capacitor c=3.73383e-18
    C920 (\3\:I1\|net9 \2\:net17) capacitor c=9.38239e-17
    C921 (\4\:I0\|N_S12 vdd!) capacitor c=6.62448e-18
    C922 (\3\:S22 \4\:S23) capacitor c=6.63161e-18
    C923 (\4\:Y0 \3\:S04) capacitor c=7.75726e-19
    C924 (\4\:net8 \2\:Y0) capacitor c=2.94155e-17
    C925 (\8\:I0\|net2 \3\:S03) capacitor c=1.32112e-18
    C926 (\146\:gnd! \6\:I1\|net10) capacitor c=5.52764e-18
    C927 (\4\:net3 X2) capacitor c=8.23318e-19
    C928 (\8\:net5 \3\:Y6) capacitor c=4.11784e-17
    C929 (\4\:I1\|N_S02 vdd!) capacitor c=7.29335e-18
    C930 (net4 \2\:I0\|N_S00) capacitor c=6.72226e-18
    C931 (\3\:Y7 \3\:S34) capacitor c=1.58091e-17
    C932 (\6\:net16 \3\:S31) capacitor c=1.12381e-17
    C933 (\2\:net7 \2\:I0\|N_S02) capacitor c=3.06186e-18
    C934 (\4\:I1\|N_S12 vdd!) capacitor c=6.79289e-18
    C935 (\3\:I1\|net10 \3\:S21) capacitor c=2.9304e-18
    C936 (X2 \2\:net16) capacitor c=1.17106e-17
    C937 (\2\:net16 \4\:I3\|N_S) capacitor c=2.54217e-18
    C938 (\67\:vdd! \5\:S03) capacitor c=6.22788e-18
    C939 (\2\:net16 \4\:net17) capacitor c=5.03278e-18
    C940 (I1\|net6 \7\:S31) capacitor c=2.05808e-18
    C941 (\1\:X2 X2) capacitor c=8.34982e-18
    C942 (I1\|net8 \3\:S32) capacitor c=7.29551e-18
    C943 (\2\:net17 \4\:S11) capacitor c=1.09368e-17
    C944 (\5\:S03 vdd!) capacitor c=8.3457e-18
    C945 (\10\:net5 \2\:net19) capacitor c=2.06551e-17
    C946 (\2\:I1\|net3 \2\:I1\|N_S01) capacitor c=3.40539e-18
    C947 (\7\:I1\|net3 \10\:I1\|net8) capacitor c=1.85806e-17
    C948 (\9\:I5\|N_S \3\:S30) capacitor c=4.68057e-18
    C949 (\5\:S13 vdd!) capacitor c=7.53581e-18
    C950 (\6\:S32 \4\:S22) capacitor c=1.00119e-17
    C951 (\3\:Y3 net6) capacitor c=1.23199e-16
    C952 (\6\:net16 \2\:net15) capacitor c=2.08508e-18
    C953 (I0\|net8 \4\:I0\|N_S11) capacitor c=2.37863e-18
    C954 (\5\:I6\|N_S \1\:S04) capacitor c=1.01333e-17
    C955 (\2\:net3 \2\:X4) capacitor c=4.90581e-17
    C956 (\2\:net6 \2\:I7\|N_S) capacitor c=9.46579e-19
    C957 (\5\:S23 vdd!) capacitor c=8.26885e-18
    C958 (\3\:Y7 \3\:I9\|N_S) capacitor c=3.88108e-18
    C959 (\5\:net17 \5\:I4\|N_S) capacitor c=1.51089e-18
    C960 (\2\:I0\|net10 I0\|N_S00) capacitor c=1.45004e-18
    C961 (\8\:I1\|net10 \4\:I1\|net2) capacitor c=5.11907e-17
    C962 (\6\:S23 \6\:S24) capacitor c=1.07895e-17
    C963 (\5\:S33 vdd!) capacitor c=7.60228e-18
    C964 (\3\:I8\|N_S \7\:S24) capacitor c=2.74811e-17
    C965 (\5\:vdd! \2\:S00) capacitor c=5.7026e-18
    C966 (net16 I3\|N_S) capacitor c=2.13302e-17
    C967 (\2\:I1\|net6 \2\:S31) capacitor c=1.55117e-17
    C968 (\10\:I1\|net3 net20) capacitor c=4.99111e-17
    C969 (\3\:Y4 \2\:I8\|N_S) capacitor c=1.01223e-18
    C970 (\8\:net3 \4\:net4) capacitor c=3.59272e-17
    C971 (\2\:S02 vdd!) capacitor c=6.57827e-18
    C972 (\8\:I1\|net8 \8\:net19) capacitor c=2.48803e-17
    C973 (\2\:I0\|net10 vdd!) capacitor c=1.48869e-17
    C974 (\2\:S10 \5\:S11) capacitor c=3.17741e-18
    C975 (\3\:I1\|net9 I1\|N_S00) capacitor c=2.09222e-18
    C976 (\6\:I1\|net3 \3\:S22) capacitor c=5.41478e-18
    C977 (\21\:vdd! \4\:S01) capacitor c=1.56938e-18
    C978 (\2\:S12 vdd!) capacitor c=6.80866e-18
    C979 (\8\:net22 \5\:net20) capacitor c=7.79168e-18
    C980 (\7\:I6\|N_S \4\:net8) capacitor c=3.52485e-17
    C981 (\9\:I0\|N_S10 I0\|net6) capacitor c=8.8453e-19
    C982 (net19 \2\:I9\|N_S) capacitor c=3.99474e-18
    C983 (\7\:net20 \3\:S33) capacitor c=4.07884e-18
    C984 (\2\:X3 \5\:I3\|N_S) capacitor c=1.1819e-17
    C985 (\5\:X0 \4\:S00) capacitor c=6.50004e-18
    C986 (\6\:I3\|N_S \2\:S10) capacitor c=1.7265e-17
    C987 (\2\:S22 vdd!) capacitor c=7.55366e-18
    C988 (\1\:S00 \6\:S01) capacitor c=1.25103e-17
    C989 (\2\:I0\|net6 vdd!) capacitor c=1.00946e-17
    C990 (\3\:S01 \3\:I0\|N_S00) capacitor c=2.71349e-17
    C991 (\2\:S32 vdd!) capacitor c=6.43561e-18
    C992 (\5\:net22 \7\:S04) capacitor c=3.31611e-18
    C993 (\2\:S02 \5\:S03) capacitor c=4.56174e-18
    C994 (\4\:net1 \1\:S11) capacitor c=2.74902e-18
    C995 (\109\:vdd! \6\:net8) capacitor c=1.23442e-17
    C996 (\7\:net16 \5\:X6) capacitor c=2.37893e-17
    C997 (\8\:I1\|net9 \9\:S22) capacitor c=3.15095e-17
    C998 (\2\:X1 \4\:I2\|N_S) capacitor c=8.25931e-19
    C999 (\6\:net2 \1\:S10) capacitor c=1.7897e-16
    C1000 (\6\:I1\|net10 \4\:I1\|net9) capacitor c=2.4098e-18
    C1001 (\2\:I0\|N_S00 \7\:S01) capacitor c=2.75072e-17
    C1002 (\3\:I5\|N_S \7\:S30) capacitor c=2.74196e-17
    C1003 (\2\:net3 \5\:I4\|N_S) capacitor c=1.38938e-18
    C1004 (\9\:S22 \10\:I0\|net8) capacitor c=3.17725e-17
    C1005 (I0\|N_S01 vdd!) capacitor c=4.65381e-18
    C1006 (\2\:I1\|net10 vdd!) capacitor c=1.00762e-17
    C1007 (\2\:net22 \6\:S23) capacitor c=2.21196e-18
    C1008 (\15\:vdd! \6\:I4\|N_S) capacitor c=3.75771e-17
    C1009 (\9\:I6\|N_S \2\:Y1) capacitor c=8.83153e-19
    C1010 (I0\|N_S11 vdd!) capacitor c=4.90667e-18
    C1011 (\2\:net1 \6\:net2) capacitor c=9.10504e-18
    C1012 (\7\:I0\|N_S02 vdd!) capacitor c=2.4857e-18
    C1013 (\6\:net21 \2\:S23) capacitor c=1.50711e-17
    C1014 (\5\:net18 \1\:X1) capacitor c=3.29428e-17
    C1015 (\5\:X6 \8\:net15) capacitor c=2.0942e-17
    C1016 (\2\:Y0 \5\:net22) capacitor c=9.86002e-18
    C1017 (\9\:net18 \3\:I1\|net9) capacitor c=6.3844e-17
    C1018 (I1\|N_S01 vdd!) capacitor c=4.26943e-18
    C1019 (\7\:I0\|N_S12 vdd!) capacitor c=3.82034e-18
    C1020 (\2\:I1\|net6 vdd!) capacitor c=9.15678e-18
    C1021 (\7\:I9\|N_S \5\:S34) capacitor c=1.64877e-17
    C1022 (\2\:I0\|net10 \3\:S01) capacitor c=1.29537e-17
    C1023 (\8\:net3 \1\:S01) capacitor c=2.21737e-18
    C1024 (\5\:I0\|net9 \8\:I0\|net5) capacitor c=1.42254e-17
    C1025 (\2\:net5 I0\|N_S12) capacitor c=1.49194e-18
    C1026 (I1\|N_S11 vdd!) capacitor c=4.86548e-18
    C1027 (\7\:I1\|N_S02 vdd!) capacitor c=3.75681e-18
    C1028 (\6\:I0\|net5 \3\:S02) capacitor c=1.313e-18
    C1029 (\3\:S32 \4\:S33) capacitor c=6.14034e-18
    C1030 (\7\:net19 \5\:S33) capacitor c=1.42725e-18
    C1031 (\3\:I0\|net8 \3\:S12) capacitor c=2.9304e-18
    C1032 (\7\:net7 net21) capacitor c=2.63242e-17
    C1033 (\2\:I1\|net10 \9\:I1\|N_S01) capacitor c=2.6311e-17
    C1034 (\3\:I0\|net5 \159\:gnd!) capacitor c=1.56454e-18
    C1035 (\1\:S02 vdd!) capacitor c=5.57776e-18
    C1036 (\7\:I1\|N_S12 vdd!) capacitor c=2.94233e-18
    C1037 (\5\:I1\|net9 \3\:S22) capacitor c=9.36143e-18
    C1038 (\4\:net6 \5\:net20) capacitor c=9.26256e-18
    C1039 (\1\:Y6 \2\:net19) capacitor c=6.73606e-17
    C1040 (\3\:I0\|net2 I0\|N_S11) capacitor c=2.38809e-18
    C1041 (net5 \4\:S13) capacitor c=5.65488e-18
    C1042 (\22\:vdd! \1\:S10) capacitor c=5.51636e-18
    C1043 (\146\:gnd! \6\:S31) capacitor c=1.87409e-18
    C1044 (\1\:S12 vdd!) capacitor c=5.30982e-18
    C1045 (\22\:vdd! \4\:S01) capacitor c=5.56613e-18
    C1046 (\5\:I7\|N_S \1\:S14) capacitor c=1.01333e-17
    C1047 (\2\:net16 \5\:net17) capacitor c=1.64355e-17
    C1048 (\4\:I1\|net2 \3\:I1\|N_S11) capacitor c=4.89986e-18
    C1049 (\1\:S22 vdd!) capacitor c=5.61074e-18
    C1050 (\4\:net15 \5\:X6) capacitor c=7.54312e-17
    C1051 (\6\:I0\|net3 \2\:I0\|N_S01) capacitor c=1.84195e-18
    C1052 (\6\:I1\|net9 \3\:I1\|N_S01) capacitor c=1.36035e-17
    C1053 (\2\:Y6 \7\:net5) capacitor c=1.17964e-18
    C1054 (\8\:I1\|net2 \8\:net21) capacitor c=1.50764e-17
    C1055 (\2\:X0 I2\|N_S) capacitor c=6.0124e-18
    C1056 (\4\:net3 \6\:net4) capacitor c=4.55287e-18
    C1057 (\140\:gnd! \2\:Y3) capacitor c=8.85162e-18
    C1058 (\2\:I0\|net8 \7\:I0\|N_S12) capacitor c=3.19027e-17
    C1059 (\2\:S20 \5\:S21) capacitor c=3.27105e-18
    C1060 (\1\:S32 vdd!) capacitor c=5.28407e-18
    C1061 (\8\:I0\|net1 \3\:net7) capacitor c=5.75175e-17
    C1062 (\4\:net17 \4\:S21) capacitor c=7.63363e-18
    C1063 (\2\:S12 \5\:S13) capacitor c=4.28989e-18
    C1064 (\10\:I0\|net10 \4\:net1) capacitor c=2.76999e-18
    C1065 (\7\:I0\|N_S02 \5\:S03) capacitor c=1.86044e-17
    C1066 (\5\:S10 \4\:S00) capacitor c=5.46767e-18
    C1067 (\8\:I1\|net10 \3\:I1\|net2) capacitor c=9.0003e-18
    C1068 (\3\:I9\|N_S \7\:S34) capacitor c=2.74512e-17
    C1069 (\9\:net18 \7\:I1\|N_S00) capacitor c=2.26125e-18
    C1070 (\4\:I0\|N_S01 vdd!) capacitor c=7.2449e-18
    C1071 (\4\:net15 \7\:S30) capacitor c=2.05808e-18
    C1072 (\4\:I0\|N_S11 vdd!) capacitor c=6.91633e-18
    C1073 (\5\:I0\|net5 vdd!) capacitor c=2.99639e-18
    C1074 (\6\:I0\|net10 \3\:S01) capacitor c=4.14713e-18
    C1075 (\6\:net22 \2\:S04) capacitor c=1.49928e-17
    C1076 (\4\:I1\|N_S01 vdd!) capacitor c=7.21642e-18
    C1077 (\3\:S02 \5\:S03) capacitor c=1.17478e-18
    C1078 (\7\:I0\|net6 vdd!) capacitor c=3.36453e-18
    C1079 (\8\:net22 Y1) capacitor c=9.69252e-18
    C1080 (\10\:I1\|net8 \7\:net19) capacitor c=7.66362e-18
    C1081 (\5\:X6 \4\:I5\|N_S) capacitor c=6.8907e-18
    C1082 (\5\:I0\|net9 \2\:I0\|net3) capacitor c=1.49001e-16
    C1083 (\8\:net2 \4\:I3\|N_S) capacitor c=1.26358e-18
    C1084 (\4\:I1\|N_S11 vdd!) capacitor c=6.92119e-18
    C1085 (\9\:I9\|N_S \4\:S34) capacitor c=4.66652e-18
    C1086 (\5\:I1\|net5 vdd!) capacitor c=3.05346e-18
    C1087 (I0\|net6 \3\:I0\|N_S10) capacitor c=6.82834e-18
    C1088 (\10\:I1\|net3 \6\:net19) capacitor c=5.53819e-18
    C1089 (S32 \8\:I1\|N_S11) capacitor c=5.89495e-17
    C1090 (\72\:vdd! \5\:S13) capacitor c=6.31164e-18
    C1091 (\5\:S02 vdd!) capacitor c=8.96252e-18
    C1092 (\7\:I1\|net6 vdd!) capacitor c=3.36537e-18
    C1093 (net21 \1\:Y5) capacitor c=3.49924e-17
    C1094 (\8\:I1\|net5 \6\:I1\|net3) capacitor c=5.16165e-17
    C1095 (\1\:X1 \4\:I2\|N_S) capacitor c=3.8312e-18
    C1096 (\3\:I0\|net9 \1\:S01) capacitor c=1.26878e-17
    C1097 (\2\:net16 \8\:net17) capacitor c=1.01248e-17
    C1098 (\3\:I0\|net2 I0\|net3) capacitor c=2.24676e-18
    C1099 (\5\:S12 vdd!) capacitor c=8.08107e-18
    C1100 (\7\:net20 \6\:net19) capacitor c=1.4089e-16
    C1101 (\7\:net21 \5\:I1\|N_S02) capacitor c=2.0442e-17
    C1102 (\7\:I0\|N_S00 \27\:vdd!) capacitor c=3.81392e-17
    C1103 (\8\:net22 \4\:Y2) capacitor c=1.73394e-18
    C1104 (\111\:vdd! \8\:net21) capacitor c=4.06062e-18
    C1105 (\2\:I0\|net3 S13) capacitor c=7.81072e-17
    C1106 (\1\:X7 \7\:S30) capacitor c=3.31574e-18
    C1107 (\5\:S22 vdd!) capacitor c=8.98047e-18
    C1108 (\2\:I1\|net8 \2\:S32) capacitor c=1.3044e-17
    C1109 (\2\:net1 \2\:I5\|N_S) capacitor c=2.23373e-18
    C1110 (\7\:net16 \3\:S30) capacitor c=4.46959e-18
    C1111 (\3\:I1\|net5 I1\|N_S10) capacitor c=2.48174e-18
    C1112 (\3\:S11 \3\:I0\|N_S10) capacitor c=2.71349e-17
    C1113 (\8\:I1\|net3 \7\:S33) capacitor c=5.01409e-18
    C1114 (I1\|net3 \4\:I1\|N_S01) capacitor c=2.40414e-18
    C1115 (\2\:net1 \2\:net3) capacitor c=6.50469e-18
    C1116 (\10\:I1\|net3 \8\:I1\|net2) capacitor c=1.79661e-16
    C1117 (\5\:S32 vdd!) capacitor c=8.06312e-18
    C1118 (\4\:net6 \2\:Y2) capacitor c=2.91569e-17
    C1119 (\2\:S22 \5\:S23) capacitor c=4.05323e-18
    C1120 (\6\:I0\|net1 \3\:I0\|N_S02) capacitor c=1.26169e-17
    C1121 (Y1 \4\:Y0) capacitor c=1.58381e-17
    C1122 (\148\:gnd! \6\:I1\|net10) capacitor c=7.20337e-17
    C1123 (\2\:I0\|N_S10 \7\:S11) capacitor c=2.74871e-17
    C1124 (\3\:I0\|net9 \5\:net3) capacitor c=1.70512e-18
    C1125 (\8\:net6 \3\:I0\|N_S12) capacitor c=5.04014e-18
    C1126 (\6\:I1\|net8 \3\:S32) capacitor c=4.41005e-18
    C1127 (\10\:I1\|net6 I1\|net8) capacitor c=7.75157e-18
    C1128 (\2\:S01 vdd!) capacitor c=8.35953e-18
    C1129 (\6\:I1\|net2 \3\:I1\|N_S02) capacitor c=1.313e-18
    C1130 (\4\:net4 \1\:S01) capacitor c=4.83149e-18
    C1131 (\4\:S00 \3\:I2\|N_S) capacitor c=2.70358e-17
    C1132 (\7\:I0\|N_S02 \3\:net7) capacitor c=2.21785e-18
    C1133 (\6\:I0\|net3 \7\:I0\|N_S12) capacitor c=5.87101e-18
    C1134 (\6\:net21 \7\:I8\|N_S) capacitor c=1.03781e-16
    C1135 (\2\:S11 vdd!) capacitor c=7.16457e-18
    C1136 (\9\:I0\|N_S10 \42\:gnd!) capacitor c=2.01886e-17
    C1137 (\6\:net3 \2\:I0\|net10) capacitor c=7.49651e-17
    C1138 (\8\:net16 \3\:I1\|N_S10) capacitor c=5.47142e-18
    C1139 (\4\:I2\|N_S \7\:S00) capacitor c=2.75643e-17
    C1140 (\6\:I1\|net8 \7\:I1\|net10) capacitor c=4.3234e-17
    C1141 (\7\:net16 \146\:gnd!) capacitor c=2.78684e-17
    C1142 (\2\:S30 \5\:S31) capacitor c=3.27105e-18
    C1143 (\140\:gnd! \3\:Y3) capacitor c=5.42784e-17
    C1144 (\9\:I0\|N_S01 I0\|net3) capacitor c=1.85966e-18
    C1145 (\2\:X6 \1\:S30) capacitor c=3.64512e-18
    C1146 (\2\:S21 vdd!) capacitor c=9.16285e-18
    C1147 (\3\:S02 \2\:I0\|N_S01) capacitor c=5.24337e-17
    C1148 (\2\:net15 \4\:S21) capacitor c=1.23563e-17
    C1149 (\5\:I8\|N_S \1\:S24) capacitor c=1.23282e-17
    C1150 (\1\:S10 \6\:S11) capacitor c=1.5672e-16
    C1151 (\111\:vdd! \9\:I8\|N_S) capacitor c=8.90357e-19
    C1152 (\2\:I0\|net3 I0\|N_S01) capacitor c=1.45004e-18
    C1153 (\2\:S31 vdd!) capacitor c=9.28725e-18
    C1154 (\10\:vdd! \2\:S10) capacitor c=5.74812e-18
    C1155 (\3\:I1\|net5 \2\:net15) capacitor c=9.48774e-17
    C1156 (I0\|N_S00 vdd!) capacitor c=5.66107e-18
    C1157 (\5\:X6 \5\:net15) capacitor c=3.1776e-17
    C1158 (\1\:X1 \6\:net4) capacitor c=5.57374e-19
    C1159 (\10\:I0\|net8 \8\:I0\|net8) capacitor c=1.99911e-18
    C1160 (\2\:I0\|net8 \2\:I0\|net3) capacitor c=4.67304e-18
    C1161 (\6\:I1\|net6 \4\:S32) capacitor c=2.41728e-18
    C1162 (\6\:net5 \2\:net6) capacitor c=5.41527e-18
    C1163 (\2\:I1\|net3 \3\:I1\|N_S02) capacitor c=1.24836e-18
    C1164 (\6\:I0\|net3 \5\:I0\|N_S12) capacitor c=6.5995e-18
    C1165 (\5\:X2 \4\:S10) capacitor c=7.84015e-18
    C1166 (\4\:net3 \6\:net2) capacitor c=1.17565e-17
    C1167 (\6\:net8 S04) capacitor c=7.65033e-18
    C1168 (\10\:I0\|net3 \5\:I0\|net1) capacitor c=3.58004e-18
    C1169 (\7\:net19 \8\:I1\|net3) capacitor c=1.61684e-16
    C1170 (\134\:gnd! \2\:net19) capacitor c=3.55782e-18
    C1171 (I0\|N_S10 vdd!) capacitor c=4.58806e-18
    C1172 (\8\:I1\|net6 \3\:I1\|net8) capacitor c=2.33199e-17
    C1173 (\3\:I1\|net1 I1\|N_S01) capacitor c=2.48861e-18
    C1174 (\3\:S12 \5\:S13) capacitor c=1.23797e-18
    C1175 (net2 \2\:I0\|N_S10) capacitor c=7.03386e-18
    C1176 (\2\:I1\|net6 \4\:S32) capacitor c=1.75923e-18
    C1177 (\7\:I0\|net10 \7\:I0\|net6) capacitor c=2.38869e-18
    C1178 (\2\:net17 \1\:S21) capacitor c=6.44523e-18
    C1179 (\2\:Y2 \5\:net22) capacitor c=8.7866e-19
    C1180 (\5\:I9\|N_S \6\:net19) capacitor c=2.28745e-17
    C1181 (I1\|N_S00 vdd!) capacitor c=6.68694e-18
    C1182 (\6\:I4\|N_S \2\:S20) capacitor c=1.83222e-17
    C1183 (Y4 \10\:S22) capacitor c=3.28161e-18
    C1184 (\3\:I0\|net10 \2\:I0\|N_S00) capacitor c=2.30726e-18
    C1185 (I0\|net8 vdd!) capacitor c=2.50865e-18
    C1186 (\3\:Y6 \2\:I9\|N_S) capacitor c=8.2432e-19
    C1187 (\3\:I1\|net6 \3\:S31) capacitor c=2.91015e-18
    C1188 (\3\:net18 X1) capacitor c=9.38963e-18
    C1189 (\5\:S20 \4\:S10) capacitor c=5.4431e-18
    C1190 (Y6 \5\:net20) capacitor c=4.02228e-18
    C1191 (\10\:I0\|net3 \3\:net7) capacitor c=1.27769e-17
    C1192 (net17 \3\:S21) capacitor c=1.51042e-18
    C1193 (\2\:net4 \3\:S01) capacitor c=9.524e-19
    C1194 (I1\|N_S10 vdd!) capacitor c=6.70488e-18
    C1195 (\2\:X5 \5\:I4\|N_S) capacitor c=1.01186e-17
    C1196 (I1\|net3 vdd!) capacitor c=2.53393e-18
    C1197 (\2\:S32 \5\:S33) capacitor c=4.55996e-18
    C1198 (\6\:I0\|net10 \6\:S12) capacitor c=2.84159e-18
    C1199 (\2\:net2 \4\:I0\|net5) capacitor c=5.24121e-17
    C1200 (\3\:Y0 \7\:S04) capacitor c=2.46014e-18
    C1201 (\1\:S01 vdd!) capacitor c=6.0691e-18
    C1202 (\3\:I0\|net2 \6\:I0\|net3) capacitor c=1.56834e-16
    C1203 (\6\:I1\|net10 \2\:I1\|net10) capacitor c=3.63468e-18
    C1204 (I1\|net8 vdd!) capacitor c=2.50865e-18
    C1205 (\9\:net18 \2\:net17) capacitor c=3.49264e-17
    C1206 (\7\:net17 I4\|N_S) capacitor c=2.13854e-17
    C1207 (\1\:S11 vdd!) capacitor c=5.34692e-18
    C1208 (\148\:gnd! \6\:S31) capacitor c=4.68168e-18
    C1209 (\2\:I0\|net3 \6\:S13) capacitor c=1.04875e-16
    C1210 (\4\:net20 \7\:S14) capacitor c=3.30188e-18
    C1211 (\6\:I0\|net8 \2\:I0\|N_S11) capacitor c=1.60147e-18
    C1212 (\8\:I1\|net5 \3\:S22) capacitor c=1.92113e-18
    C1213 (\1\:S21 vdd!) capacitor c=5.63753e-18
    C1214 (\8\:I1\|net2 \3\:S23) capacitor c=1.63596e-18
    C1215 (\2\:net17 \7\:I1\|N_S00) capacitor c=7.07663e-17
    C1216 (\2\:net5 \8\:I0\|net3) capacitor c=6.01008e-18
    C1217 (\6\:I5\|N_S \4\:net15) capacitor c=4.60363e-17
    C1218 (\2\:Y7 \5\:Y7) capacitor c=3.36387e-18
    C1219 (\7\:I7\|N_S \4\:net6) capacitor c=2.71517e-17
    C1220 (\1\:S31 vdd!) capacitor c=5.36919e-18
    C1221 (\5\:net20 \2\:S14) capacitor c=1.569e-17
    C1222 (\6\:net4 \5\:S00) capacitor c=1.18302e-18
    C1223 (S31 \4\:S20) capacitor c=8.2796e-18
    C1224 (\7\:I0\|N_S12 \5\:S13) capacitor c=1.9569e-17
    C1225 (\7\:net21 \4\:S23) capacitor c=6.34428e-18
    C1226 (\2\:X3 \4\:I3\|N_S) capacitor c=8.23774e-19
    C1227 (\4\:I0\|N_S00 vdd!) capacitor c=8.06622e-18
    C1228 (\4\:net15 \9\:I5\|N_S) capacitor c=4.03391e-17
    C1229 (\2\:S14 \3\:S04) capacitor c=5.67684e-18
    C1230 (\7\:net16 \3\:I1\|net5) capacitor c=1.84258e-18
    C1231 (\2\:net18 \3\:X0) capacitor c=1.30736e-16
    C1232 (\3\:I0\|net1 \2\:I0\|net3) capacitor c=9.2461e-18
    C1233 (\2\:net5 \2\:I0\|N_S12) capacitor c=3.43574e-18
    C1234 (\4\:I0\|N_S10 vdd!) capacitor c=7.36367e-18
    C1235 (\10\:I0\|net3 \3\:S03) capacitor c=2.73985e-18
    C1236 (\4\:I1\|N_S00 vdd!) capacitor c=7.25791e-18
    C1237 (\7\:net7 Y4) capacitor c=1.08496e-17
    C1238 (\5\:I9\|N_S \1\:S34) capacitor c=1.18611e-17
    C1239 (\6\:I0\|net6 \3\:S11) capacitor c=2.977e-18
    C1240 (\3\:I0\|net5 \1\:S11) capacitor c=1.26803e-17
    C1241 (\3\:S21 \3\:I1\|N_S00) capacitor c=2.71349e-17
    C1242 (\4\:I1\|N_S10 vdd!) capacitor c=6.85986e-18
    C1243 (\2\:I1\|net10 \5\:I1\|net10) capacitor c=4.74776e-18
    C1244 (\4\:net3 S20) capacitor c=1.1829e-17
    C1245 (\6\:net5 \140\:gnd!) capacitor c=1.38207e-17
    C1246 (I0\|N_S01 \2\:S02) capacitor c=2.21012e-17
    C1247 (\4\:net4 \3\:I0\|net9) capacitor c=5.80885e-17
    C1248 (\2\:I1\|N_S00 \7\:S21) capacitor c=2.75072e-17
    C1249 (\5\:S01 vdd!) capacitor c=8.89687e-18
    C1250 (\77\:vdd! \5\:S23) capacitor c=6.22788e-18
    C1251 (\6\:net19 \4\:S34) capacitor c=1.66946e-18
    C1252 (\111\:vdd! \6\:net19) capacitor c=1.0018e-17
    C1253 (\4\:net2 \4\:S01) capacitor c=1.22845e-17
    C1254 (\2\:I0\|net6 I0\|N_S10) capacitor c=1.3963e-18
    C1255 (\3\:S12 \2\:I0\|N_S11) capacitor c=5.24677e-17
    C1256 (\4\:net8 \2\:S04) capacitor c=8.00144e-19
    C1257 (\8\:I0\|net6 \3\:S12) capacitor c=1.313e-18
    C1258 (\5\:S11 vdd!) capacitor c=8.95139e-18
    C1259 (\5\:I1\|N_S02 \6\:S23) capacitor c=3.6628e-17
    C1260 (\2\:Y2 \4\:net20) capacitor c=9.86002e-18
    C1261 (\10\:net7 \2\:net21) capacitor c=7.82644e-18
    C1262 (\5\:net1 \3\:I0\|net6) capacitor c=2.31543e-17
    C1263 (\3\:I1\|net3 \3\:S22) capacitor c=2.9304e-18
    C1264 (\2\:net16 S20) capacitor c=6.21912e-18
    C1265 (\7\:net7 \12\:net5) capacitor c=3.74635e-16
    C1266 (\2\:I0\|net10 \2\:net4) capacitor c=5.87398e-18
    C1267 (\4\:net8 \1\:Y0) capacitor c=2.86862e-17
    C1268 (\7\:I1\|net10 \3\:S32) capacitor c=1.0356e-17
    C1269 (\1\:X4 \5\:net17) capacitor c=8.26297e-18
    C1270 (\5\:I0\|net9 \2\:I0\|N_S01) capacitor c=7.02262e-18
    C1271 (\2\:Y0 \2\:Y1) capacitor c=8.00208e-19
    C1272 (\8\:net8 \8\:I0\|net2) capacitor c=1.60967e-17
    C1273 (\4\:S10 \3\:I3\|N_S) capacitor c=2.70358e-17
    C1274 (\6\:net5 \2\:I0\|N_S12) capacitor c=1.42102e-18
    C1275 (\5\:S21 vdd!) capacitor c=7.35259e-18
    C1276 (\6\:S11 \4\:S00) capacitor c=1.74067e-18
    C1277 (net5 \10\:I0\|net3) capacitor c=5.48204e-17
    C1278 (\4\:I3\|N_S \7\:S10) capacitor c=2.75643e-17
    C1279 (S12 \5\:S02) capacitor c=1.79448e-18
    C1280 (\5\:S31 vdd!) capacitor c=9.15183e-18
    C1281 (\6\:I1\|N_S11 \77\:gnd!) capacitor c=1.13327e-18
    C1282 (\5\:I0\|net2 \2\:S03) capacitor c=4.9878e-18
    C1283 (S10 \4\:S00) capacitor c=1.67491e-18
    C1284 (\7\:net16 net1) capacitor c=4.70472e-18
    C1285 (\8\:I0\|net5 \2\:I0\|N_S01) capacitor c=2.26383e-18
    C1286 (\140\:gnd! \3\:S14) capacitor c=2.52397e-18
    C1287 (\9\:S22 \7\:I1\|N_S02) capacitor c=4.54468e-18
    C1288 (\8\:I0\|net2 \2\:I0\|N_S02) capacitor c=2.21226e-18
    C1289 (\2\:S00 vdd!) capacitor c=8.01453e-18
    C1290 (\2\:X2 I3\|N_S) capacitor c=2.98066e-18
    C1291 (\9\:I7\|N_S \6\:Y3) capacitor c=8.83153e-19
    C1292 (I1\|net8 \4\:I1\|N_S11) capacitor c=2.37863e-18
    C1293 (\8\:I1\|net10 \3\:I1\|N_S11) capacitor c=1.42929e-17
    C1294 (\10\:net5 \1\:Y6) capacitor c=5.03437e-17
    C1295 (\10\:I1\|net6 \6\:I1\|net8) capacitor c=2.48592e-17
    C1296 (\2\:S10 vdd!) capacitor c=1.00086e-17
    C1297 (\4\:net7 \7\:I6\|N_S) capacitor c=1.07571e-17
    C1298 (\2\:Y3 \2\:I7\|N_S) capacitor c=1.36604e-18
    C1299 (\3\:X2 \8\:net2) capacitor c=5.30346e-17
    C1300 (\7\:I0\|N_S01 vdd!) capacitor c=2.38965e-18
    C1301 (\2\:S24 \3\:S14) capacitor c=5.47499e-18
    C1302 (\7\:I0\|net10 \10\:I0\|net6) capacitor c=1.39693e-17
    C1303 (\3\:I0\|net1 \1\:S02) capacitor c=1.39969e-17
    C1304 (\8\:net22 \2\:S04) capacitor c=1.42846e-18
    C1305 (\2\:I1\|net8 \2\:I1\|N_S11) capacitor c=3.47895e-18
    C1306 (\5\:S30 \4\:S20) capacitor c=5.40346e-18
    C1307 (\6\:I1\|net10 I1\|net10) capacitor c=4.89733e-18
    C1308 (\2\:S20 vdd!) capacitor c=7.95755e-18
    C1309 (\3\:I1\|net2 I1\|N_S11) capacitor c=2.38198e-18
    C1310 (I1\|net10 \3\:I1\|N_S00) capacitor c=6.23705e-18
    C1311 (\6\:I0\|N_S11 vdd!) capacitor c=4.17505e-18
    C1312 (\20\:vdd! \6\:I5\|N_S) capacitor c=3.85185e-17
    C1313 (\1\:S20 \6\:S21) capacitor c=1.32004e-16
    C1314 (\5\:I0\|net1 \3\:S03) capacitor c=9.22534e-18
    C1315 (\7\:net19 \5\:I1\|N_S12) capacitor c=2.30439e-17
    C1316 (\2\:net20 \10\:I1\|net3) capacitor c=5.74089e-18
    C1317 (\8\:net8 \6\:I0\|net2) capacitor c=2.35327e-17
    C1318 (\3\:net5 \2\:net5) capacitor c=5.12406e-18
    C1319 (\2\:S30 vdd!) capacitor c=9.44938e-18
    C1320 (\4\:net2 \1\:S11) capacitor c=6.74289e-18
    C1321 (\7\:I1\|N_S01 vdd!) capacitor c=3.57819e-18
    C1322 (\10\:I1\|net8 \8\:net19) capacitor c=1.40266e-17
    C1323 (\3\:I0\|net5 \5\:I0\|N_S11) capacitor c=1.94083e-18
    C1324 (\2\:I1\|net3 \9\:I1\|N_S02) capacitor c=2.45422e-17
    C1325 (\5\:net15 \5\:I5\|N_S) capacitor c=1.51089e-18
    C1326 (\9\:I1\|N_S00 I1\|net10) capacitor c=1.85966e-18
    C1327 (I0\|net3 \5\:S02) capacitor c=1.41627e-18
    C1328 (\2\:I2\|N_S vdd!) capacitor c=5.61804e-18
    C1329 (\10\:S22 \5\:net20) capacitor c=2.0784e-17
    C1330 (\6\:I1\|N_S11 vdd!) capacitor c=2.9258e-18
    C1331 (I0\|N_S11 \2\:S12) capacitor c=2.20164e-17
    C1332 (\2\:net18 \6\:S11) capacitor c=3.95148e-17
    C1333 (\12\:net5 Y2) capacitor c=5.60613e-17
    C1334 (\10\:net7 \2\:Y4) capacitor c=3.01664e-17
    C1335 (\2\:I3\|N_S vdd!) capacitor c=6.84858e-18
    C1336 (\5\:I0\|N_S01 \1\:S02) capacitor c=1.30381e-17
    C1337 (\2\:net5 \3\:I7\|N_S) capacitor c=1.19702e-18
    C1338 (\3\:X0 \4\:S00) capacitor c=8.86988e-19
    C1339 (\4\:net17 \2\:S20) capacitor c=1.85587e-18
    C1340 (\108\:vdd! \2\:Y0) capacitor c=4.25289e-18
    C1341 (\8\:net22 Y2) capacitor c=8.60313e-18
    C1342 (S32 \3\:I1\|N_S11) capacitor c=1.16809e-18
    C1343 (\2\:I4\|N_S vdd!) capacitor c=6.80561e-18
    C1344 (\2\:net18 \3\:X2) capacitor c=1.20017e-17
    C1345 (net2 \2\:I0\|net6) capacitor c=1.49355e-16
    C1346 (\159\:gnd! \6\:S11) capacitor c=5.55708e-18
    C1347 (\2\:I5\|N_S vdd!) capacitor c=6.89028e-18
    C1348 (\3\:Y3 \2\:I7\|N_S) capacitor c=2.45266e-18
    C1349 (\5\:X4 \4\:S20) capacitor c=6.3817e-18
    C1350 (\15\:vdd! \2\:S20) capacitor c=5.7026e-18
    C1351 (\8\:I0\|net3 \3\:I0\|N_S12) capacitor c=1.44266e-17
    C1352 (\109\:vdd! \6\:S14) capacitor c=4.63683e-18
    C1353 (\3\:S32 \5\:S33) capacitor c=1.17214e-18
    C1354 (\6\:net19 \2\:S33) capacitor c=1.51822e-17
    C1355 (\6\:S00 vdd!) capacitor c=6.73158e-18
    C1356 (net22 \3\:I1\|N_S02) capacitor c=4.9557e-18
    C1357 (\2\:I0\|net3 vdd!) capacitor c=1.49352e-17
    C1358 (\4\:net22 \97\:vdd!) capacitor c=3.04609e-18
    C1359 (\2\:net21 \2\:S24) capacitor c=1.39716e-17
    C1360 (\10\:I1\|net8 \3\:S33) capacitor c=3.29568e-18
    C1361 (\8\:I1\|net8 \3\:I1\|N_S12) capacitor c=9.09266e-19
    C1362 (\158\:gnd! \7\:I0\|N_S10) capacitor c=1.47114e-17
    C1363 (\2\:net15 \1\:S31) capacitor c=6.20712e-18
    C1364 (S32 \4\:S32) capacitor c=9.72192e-18
    C1365 (net3 \4\:I4\|N_S) capacitor c=1.36698e-18
    C1366 (\9\:S22 \70\:gnd!) capacitor c=3.07562e-18
    C1367 (\6\:S10 vdd!) capacitor c=6.03104e-18
    C1368 (\6\:I1\|net3 \2\:I1\|N_S01) capacitor c=1.84195e-18
    C1369 (\6\:net3 vdd!) capacitor c=2.97512e-18
    C1370 (\10\:I1\|net6 \3\:S32) capacitor c=3.14933e-18
    C1371 (\4\:net1 \2\:I0\|net10) capacitor c=2.70742e-18
    C1372 (\6\:S20 vdd!) capacitor c=6.53782e-18
    C1373 (\2\:S34 \3\:S24) capacitor c=5.47499e-18
    C1374 (\13\:net5 Y2) capacitor c=6.58951e-17
    C1375 (\4\:net1 vdd!) capacitor c=3.16482e-18
    C1376 (\3\:Y3 \4\:S14) capacitor c=2.56322e-18
    C1377 (\2\:S12 \3\:S02) capacitor c=7.51052e-18
    C1378 (\6\:I5\|N_S \2\:S30) capacitor c=1.7249e-17
    C1379 (\6\:I0\|net6 \6\:S22) capacitor c=1.76873e-18
    C1380 (\2\:I0\|net8 vdd!) capacitor c=1.16266e-17
    C1381 (\1\:X3 \4\:I3\|N_S) capacitor c=3.8312e-18
    C1382 (\2\:net15 \6\:S32) capacitor c=1.13175e-17
    C1383 (\159\:gnd! I0\|net10) capacitor c=1.34861e-17
    C1384 (\109\:vdd! \6\:net6) capacitor c=1.00045e-17
    C1385 (\2\:I0\|net6 \3\:S11) capacitor c=1.36457e-17
    C1386 (\6\:S30 vdd!) capacitor c=5.76429e-18
    C1387 (\8\:net5 \2\:I9\|N_S) capacitor c=9.46579e-19
    C1388 (\2\:net17 vdd!) capacitor c=6.01067e-18
    C1389 (\3\:S31 \3\:I1\|N_S10) capacitor c=2.71196e-17
    C1390 (\3\:S22 \2\:I1\|N_S01) capacitor c=5.24337e-17
    C1391 (\2\:net16 X4) capacitor c=1.06907e-18
    C1392 (S32 \3\:S31) capacitor c=3.7451e-18
    C1393 (\2\:net16 \4\:S10) capacitor c=1.73068e-17
    C1394 (\6\:net4 I2\|N_S) capacitor c=9.56268e-17
    C1395 (\5\:net18 \4\:I2\|N_S) capacitor c=3.61624e-18
    C1396 (\2\:net16 \5\:net15) capacitor c=1.2087e-17
    C1397 (\8\:net3 I0\|net10) capacitor c=3.53911e-18
    C1398 (\5\:I2\|N_S vdd!) capacitor c=7.45818e-18
    C1399 (\2\:net15 vdd!) capacitor c=4.89156e-18
    C1400 (\7\:I1\|N_S02 \5\:S23) capacitor c=1.9125e-17
    C1401 (\2\:I1\|N_S10 \7\:S31) capacitor c=2.7322e-17
    C1402 (\2\:I1\|net3 vdd!) capacitor c=1.16654e-17
    C1403 (\1\:S30 S31) capacitor c=2.25148e-17
    C1404 (\2\:X7 \5\:I5\|N_S) capacitor c=1.12185e-17
    C1405 (I1\|N_S01 \2\:S22) capacitor c=2.21859e-17
    C1406 (\7\:I0\|N_S12 net5) capacitor c=1.84883e-18
    C1407 (S33 \3\:I1\|N_S12) capacitor c=9.52871e-19
    C1408 (\2\:net8 \7\:S04) capacitor c=5.24165e-18
    C1409 (I0\|net3 \5\:I0\|N_S01) capacitor c=2.15393e-17
    C1410 (net18 \3\:S00) capacitor c=7.86206e-19
    C1411 (\3\:I1\|net9 \1\:S21) capacitor c=1.04825e-17
    C1412 (\5\:I3\|N_S vdd!) capacitor c=6.44304e-18
    C1413 (\6\:net8 \2\:S03) capacitor c=8.60235e-18
    C1414 (\8\:net15 \7\:S30) capacitor c=1.3739e-18
    C1415 (\6\:I1\|net10 \2\:I1\|net6) capacitor c=4.45114e-18
    C1416 (\5\:I4\|N_S vdd!) capacitor c=6.76282e-18
    C1417 (\7\:I0\|N_S10 \32\:vdd!) capacitor c=3.7561e-17
    C1418 (\2\:I1\|net8 vdd!) capacitor c=1.027e-17
    C1419 (\3\:Y2 \7\:S14) capacitor c=2.44591e-18
    C1420 (\10\:S22 \2\:net21) capacitor c=1.48849e-17
    C1421 (\2\:X1 \5\:S00) capacitor c=1.59649e-17
    C1422 (\7\:net19 \4\:S33) capacitor c=6.96222e-18
    C1423 (\21\:vdd! \3\:S00) capacitor c=1.49344e-18
    C1424 (\2\:Y6 \1\:Y7) capacitor c=6.88301e-18
    C1425 (\5\:I5\|N_S vdd!) capacitor c=7.12639e-18
    C1426 (\6\:I1\|net10 \7\:net18) capacitor c=3.19458e-18
    C1427 (\108\:vdd! \4\:S04) capacitor c=1.75815e-18
    C1428 (\6\:I1\|net10 \3\:S21) capacitor c=3.53863e-18
    C1429 (\4\:S20 \3\:I4\|N_S) capacitor c=2.70358e-17
    C1430 (net21 \7\:S24) capacitor c=3.31611e-18
    C1431 (\5\:net16 \1\:X3) capacitor c=3.29428e-17
    C1432 (\2\:I0\|net3 \4\:S03) capacitor c=1.74459e-18
    C1433 (I0\|net10 \2\:net4) capacitor c=1.62651e-16
    C1434 (S33 \4\:S33) capacitor c=9.83295e-18
    C1435 (S33 \9\:I1\|N_S12) capacitor c=5.90005e-17
    C1436 (net18 \3\:X0) capacitor c=3.01891e-17
    C1437 (\5\:S00 vdd!) capacitor c=1.4072e-17
    C1438 (\158\:gnd! \6\:I0\|net10) capacitor c=5.45371e-18
    C1439 (\3\:I0\|net5 \5\:net1) capacitor c=1.67151e-18
    C1440 (net19 \1\:Y7) capacitor c=3.29653e-17
    C1441 (\82\:vdd! \5\:S33) capacitor c=6.31164e-18
    C1442 (\4\:I4\|N_S \7\:S20) capacitor c=2.75113e-17
    C1443 (\6\:net18 \2\:I1\|N_S00) capacitor c=6.72226e-18
    C1444 (\2\:Y2 \6\:S14) capacitor c=8.24786e-19
    C1445 (\5\:S10 vdd!) capacitor c=1.5181e-17
    C1446 (\2\:net7 \5\:net7) capacitor c=4.92705e-18
    C1447 (\6\:S21 \4\:S10) capacitor c=1.69626e-18
    C1448 (\4\:net4 vdd!) capacitor c=5.23894e-18
    C1449 (\2\:net1 \3\:X0) capacitor c=1.17158e-18
    C1450 (\3\:I0\|net6 \2\:I0\|N_S10) capacitor c=2.29986e-18
    C1451 (\5\:net3 \2\:I0\|N_S00) capacitor c=3.99521e-18
    C1452 (\5\:S20 vdd!) capacitor c=1.38234e-17
    C1453 (S21 \4\:S10) capacitor c=7.48414e-18
    C1454 (\3\:I0\|net2 \1\:S12) capacitor c=1.1973e-17
    C1455 (\7\:I0\|net8 \2\:S13) capacitor c=4.80954e-18
    C1456 (\4\:net2 vdd!) capacitor c=4.85182e-18
    C1457 (\10\:I0\|net8 \2\:I0\|N_S12) capacitor c=1.62055e-18
    C1458 (\6\:S13 \3\:I0\|N_S02) capacitor c=1.24956e-18
    C1459 (net15 \3\:S31) capacitor c=1.47734e-18
    C1460 (\7\:net15 I5\|N_S) capacitor c=2.14423e-17
    C1461 (\2\:net18 \6\:S21) capacitor c=7.68904e-18
    C1462 (I0\|net3 \7\:S02) capacitor c=2.04708e-18
    C1463 (\8\:I0\|net9 \1\:S02) capacitor c=2.01136e-18
    C1464 (\2\:net16 \6\:X2) capacitor c=2.70378e-17
    C1465 (\5\:I0\|N_S11 \1\:S12) capacitor c=1.25007e-17
    C1466 (\5\:S30 vdd!) capacitor c=1.3818e-17
    C1467 (\5\:net15 \2\:X7) capacitor c=9.48503e-17
    C1468 (\10\:I0\|net6 \2\:I0\|N_S11) capacitor c=2.16917e-18
    C1469 (S33 \3\:S32) capacitor c=3.72149e-18
    C1470 (\7\:I0\|N_S01 I0\|net3) capacitor c=2.21785e-18
    C1471 (\3\:S04 vdd!) capacitor c=2.35945e-18
    C1472 (\7\:net20 \7\:I9\|N_S) capacitor c=1.73337e-17
    C1473 (\10\:net16 vdd!) capacitor c=3.51391e-18
    C1474 (\2\:X5 \4\:I4\|N_S) capacitor c=8.24198e-19
    C1475 (\4\:net22 I1\|N_S02) capacitor c=1.00312e-18
    C1476 (\108\:vdd! \119\:gnd!) capacitor c=9.1177e-18
    C1477 (\2\:I0\|net8 I0\|N_S11) capacitor c=1.47765e-18
    C1478 (\3\:S14 vdd!) capacitor c=2.35358e-18
    C1479 (I1\|N_S11 \2\:S32) capacitor c=2.20164e-17
    C1480 (I0\|net10 vdd!) capacitor c=2.5387e-18
    C1481 (\7\:net1 \4\:I0\|net5) capacitor c=1.91454e-17
    C1482 (\2\:S22 \3\:S12) capacitor c=7.46192e-18
    C1483 (I0\|net10 \4\:S01) capacitor c=5.63431e-18
    C1484 (\159\:gnd! \6\:S12) capacitor c=5.37704e-18
    C1485 (\8\:I0\|N_S11 I0\|net8) capacitor c=1.48023e-18
    C1486 (\7\:I6\|N_S \2\:Y1) capacitor c=1.04744e-18
    C1487 (\3\:S24 vdd!) capacitor c=2.35631e-18
    C1488 (I0\|net6 vdd!) capacitor c=2.77191e-18
    C1489 (\2\:net18 \22\:vdd!) capacitor c=1.07793e-17
    C1490 (\10\:net5 \5\:I9\|N_S) capacitor c=1.13564e-17
    C1491 (\3\:I0\|net2 \2\:I0\|net3) capacitor c=3.34422e-18
    C1492 (\1\:S30 \6\:S31) capacitor c=1.19851e-16
    C1493 (\7\:net7 \3\:S24) capacitor c=6.65801e-18
    C1494 (\9\:net18 \1\:S21) capacitor c=2.6566e-18
    C1495 (\3\:S34 vdd!) capacitor c=2.42538e-18
    C1496 (\111\:vdd! \8\:I1\|net1) capacitor c=6.17787e-18
    C1497 (I1\|net10 vdd!) capacitor c=2.56548e-18
    C1498 (net18 \2\:S00) capacitor c=1.50264e-18
    C1499 (\22\:vdd! \3\:S00) capacitor c=1.72008e-17
    C1500 (\2\:I6\|N_S vdd!) capacitor c=1.1267e-18
    C1501 (I1\|net6 vdd!) capacitor c=2.77319e-18
    C1502 (\5\:I1\|net9 \5\:I1\|net5) capacitor c=2.38632e-18
    C1503 (\4\:net15 \4\:S31) capacitor c=8.24412e-18
    C1504 (\5\:net15 X7) capacitor c=1.36517e-17
    C1505 (\6\:I0\|net9 \3\:S02) capacitor c=9.524e-19
    C1506 (\2\:I7\|N_S vdd!) capacitor c=1.1267e-18
    C1507 (\4\:net3 \6\:S20) capacitor c=5.35615e-18
    C1508 (I0\|net8 \5\:S12) capacitor c=1.30241e-18
    C1509 (\6\:I0\|net10 \2\:I0\|N_S00) capacitor c=2.39268e-18
    C1510 (\2\:net16 \4\:S20) capacitor c=2.13603e-18
    C1511 (\2\:net19 \2\:S34) capacitor c=1.31588e-17
    C1512 (\3\:net18 \5\:S00) capacitor c=1.18639e-17
    C1513 (\2\:I8\|N_S vdd!) capacitor c=1.1267e-18
    C1514 (\3\:S32 \2\:I1\|N_S11) capacitor c=5.25448e-17
    C1515 (\4\:net3 \2\:X1) capacitor c=5.01161e-18
    C1516 (\8\:I1\|net1 \7\:net21) capacitor c=5.78174e-17
    C1517 (\6\:I1\|net5 \3\:S22) capacitor c=1.313e-18
    C1518 (\4\:net6 \1\:Y2) capacitor c=2.86862e-17
    C1519 (\2\:net15 \7\:I1\|N_S10) capacitor c=6.77786e-17
    C1520 (\3\:I1\|net8 \3\:S32) capacitor c=2.92709e-18
    C1521 (\4\:net2 \3\:I0\|net5) capacitor c=5.98305e-17
    C1522 (\2\:I9\|N_S vdd!) capacitor c=1.14e-18
    C1523 (\5\:net20 \2\:Y3) capacitor c=1.7767e-16
    C1524 (\3\:I0\|net3 \2\:I0\|N_S01) capacitor c=2.30726e-18
    C1525 (\7\:I0\|net10 \2\:I0\|N_S11) capacitor c=6.94411e-18
    C1526 (\2\:I0\|net3 \5\:I0\|net3) capacitor c=2.88831e-18
    C1527 (\6\:I1\|net3 \5\:I1\|N_S12) capacitor c=6.5995e-18
    C1528 (\8\:I0\|net9 I0\|net3) capacitor c=5.76228e-17
    C1529 (\5\:I0\|N_S12 \4\:S03) capacitor c=4.97135e-18
    C1530 (\7\:S04 vdd!) capacitor c=9.64979e-19
    C1531 (\111\:vdd! \4\:net22) capacitor c=2.88946e-17
    C1532 (\2\:Y4 net21) capacitor c=9.86002e-18
    C1533 (\3\:I0\|N_S00 \7\:S01) capacitor c=2.72636e-17
    C1534 (I1\|net6 \3\:I1\|N_S10) capacitor c=6.97474e-18
    C1535 (\1\:X3 \6\:net2) capacitor c=5.57284e-19
    C1536 (\6\:I1\|net8 \2\:I1\|N_S11) capacitor c=1.60147e-18
    C1537 (net8 \6\:net22) capacitor c=2.21606e-18
    C1538 (net7 \3\:S03) capacitor c=4.97394e-18
    C1539 (\3\:I0\|net9 \4\:I0\|N_S00) capacitor c=2.02929e-18
    C1540 (\159\:gnd! \6\:I0\|net10) capacitor c=7.22289e-17
    C1541 (\9\:I1\|N_S00 \49\:gnd!) capacitor c=2.07334e-17
    C1542 (\1\:S02 I0\|N_S01) capacitor c=2.19228e-17
    C1543 (\5\:I0\|N_S11 I0\|net3) capacitor c=1.30176e-17
    C1544 (\4\:net17 \4\:I4\|N_S) capacitor c=2.37377e-18
    C1545 (\4\:I0\|net1 \6\:I0\|net5) capacitor c=2.2447e-17
    C1546 (\2\:X4 I4\|N_S) capacitor c=3.338e-18
    C1547 (\10\:I1\|net3 \3\:S23) capacitor c=3.71212e-18
    C1548 (\7\:I0\|net3 \3\:S13) capacitor c=9.16228e-18
    C1549 (\5\:X6 \4\:S30) capacitor c=6.65373e-18
    C1550 (\10\:I0\|net8 \8\:net6) capacitor c=1.58742e-17
    C1551 (\3\:I1\|net5 \1\:S31) capacitor c=1.05736e-17
    C1552 (\6\:net22 I6\|N_S) capacitor c=1.06819e-17
    C1553 (\2\:net1 \3\:X2) capacitor c=3.76252e-18
    C1554 (\6\:S23 net5) capacitor c=3.70762e-17
    C1555 (\10\:I0\|net3 net7) capacitor c=5.98478e-18
    C1556 (\10\:I1\|net10 \2\:net15) capacitor c=3.75687e-18
    C1557 (\20\:vdd! \2\:S30) capacitor c=5.74812e-18
    C1558 (\3\:I6\|N_S vdd!) capacitor c=2.28212e-18
    C1559 (\6\:net6 \2\:S13) capacitor c=4.86125e-18
    C1560 (\7\:I1\|N_S12 \5\:S33) capacitor c=1.90675e-17
    C1561 (\6\:I0\|net3 \6\:S13) capacitor c=2.10094e-17
    C1562 (\2\:net16 \6\:X4) capacitor c=3.69913e-18
    C1563 (\6\:I1\|net10 \6\:S32) capacitor c=2.97633e-18
    C1564 (\3\:I7\|N_S vdd!) capacitor c=2.28212e-18
    C1565 (\2\:S32 \3\:S22) capacitor c=7.51052e-18
    C1566 (\5\:I1\|N_S01 \1\:S22) capacitor c=1.3131e-17
    C1567 (\4\:S30 \3\:I5\|N_S) capacitor c=2.70205e-17
    C1568 (\2\:I1\|net3 \7\:I1\|N_S02) capacitor c=3.08867e-17
    C1569 (\2\:net1 \6\:S30) capacitor c=1.22631e-17
    C1570 (\5\:net17 \6\:X4) capacitor c=6.11704e-17
    C1571 (\1\:S10 \4\:S00) capacitor c=1.14606e-18
    C1572 (\3\:I8\|N_S vdd!) capacitor c=2.28212e-18
    C1573 (\4\:I5\|N_S \7\:S30) capacitor c=2.75938e-17
    C1574 (\10\:I0\|net3 I0\|N_S12) capacitor c=1.02927e-18
    C1575 (\159\:gnd! \2\:I0\|net10) capacitor c=1.2846e-17
    C1576 (\1\:X4 \4\:S20) capacitor c=1.32861e-18
    C1577 (\2\:I1\|net10 I1\|N_S00) capacitor c=1.45311e-18
    C1578 (\3\:I1\|net1 \1\:S22) capacitor c=1.28659e-17
    C1579 (\3\:I9\|N_S vdd!) capacitor c=2.39648e-18
    C1580 (\7\:net18 \4\:I1\|net9) capacitor c=5.25119e-17
    C1581 (\5\:I1\|net9 \8\:I1\|net5) capacitor c=1.42254e-17
    C1582 (\10\:I0\|net10 \1\:S12) capacitor c=2.01079e-18
    C1583 (\3\:I1\|net2 I1\|net3) capacitor c=2.24676e-18
    C1584 (\2\:X1 \6\:net4) capacitor c=8.36614e-17
    C1585 (\109\:vdd! \5\:I0\|net1) capacitor c=1.25119e-17
    C1586 (\9\:I8\|N_S \4\:Y5) capacitor c=8.83153e-19
    C1587 (\6\:S00 \2\:I2\|N_S) capacitor c=1.59195e-17
    C1588 (\6\:I1\|net6 \3\:S31) capacitor c=4.41095e-18
    C1589 (\3\:S03 \4\:S04) capacitor c=7.08386e-18
    C1590 (\6\:I1\|net1 \3\:I1\|N_S02) capacitor c=1.26169e-17
    C1591 (\13\:net5 net6) capacitor c=4.84255e-18
    C1592 (\8\:net22 Y0) capacitor c=2.06408e-17
    C1593 (\8\:I1\|net2 \2\:I1\|N_S02) capacitor c=2.21226e-18
    C1594 (\3\:I1\|N_S12 \3\:net20) capacitor c=3.09299e-18
    C1595 (\3\:I1\|net2 \6\:I1\|net3) capacitor c=1.56821e-16
    C1596 (\5\:I1\|net2 \2\:S23) capacitor c=5.20506e-18
    C1597 (\7\:I0\|N_S00 vdd!) capacitor c=2.93863e-18
    C1598 (\8\:I0\|net5 \3\:I0\|net2) capacitor c=1.60305e-17
    C1599 (\6\:I1\|net3 \7\:I1\|N_S12) capacitor c=5.87101e-18
    C1600 (\7\:I0\|N_S10 vdd!) capacitor c=5.40626e-18
    C1601 (\1\:S12 I0\|N_S11) capacitor c=2.18406e-17
    C1602 (\4\:net22 \6\:net21) capacitor c=2.75181e-17
    C1603 (\5\:net17 \4\:I4\|N_S) capacitor c=1.81515e-18
    C1604 (\8\:I1\|net5 \2\:I1\|N_S01) capacitor c=2.26383e-18
    C1605 (\3\:X2 \4\:S10) capacitor c=9.61737e-19
    C1606 (\158\:gnd! I0\|net6) capacitor c=2.13987e-18
    C1607 (\7\:I1\|N_S00 vdd!) capacitor c=2.6201e-18
    C1608 (\2\:net6 \7\:S14) capacitor c=5.11213e-18
    C1609 (I0\|net8 \5\:I0\|N_S11) capacitor c=2.31939e-17
    C1610 (\3\:S02 \3\:I0\|N_S01) capacitor c=2.71349e-17
    C1611 (\3\:S03 vdd!) capacitor c=2.45513e-18
    C1612 (\1\:S14 \3\:S04) capacitor c=5.45127e-18
    C1613 (\2\:X3 \5\:S10) capacitor c=1.59679e-17
    C1614 (\4\:net3 \2\:X3) capacitor c=9.17918e-18
    C1615 (\7\:I1\|N_S10 vdd!) capacitor c=4.37638e-18
    C1616 (net16 \3\:S10) capacitor c=3.24454e-18
    C1617 (\2\:I0\|N_S01 \7\:S02) capacitor c=2.74354e-17
    C1618 (\3\:Y4 \7\:S24) capacitor c=2.46014e-18
    C1619 (\7\:net16 \2\:X7) capacitor c=2.06656e-18
    C1620 (\8\:I1\|net1 \9\:S22) capacitor c=2.98294e-17
    C1621 (\3\:S13 vdd!) capacitor c=2.57194e-18
    C1622 (\6\:I2\|N_S vdd!) capacitor c=2.4185e-18
    C1623 (\6\:net2 I3\|N_S) capacitor c=9.7393e-17
    C1624 (\1\:Y1 \2\:I6\|N_S) capacitor c=2.72658e-18
    C1625 (\7\:net5 \2\:Y7) capacitor c=2.60401e-17
    C1626 (\3\:S23 vdd!) capacitor c=2.5252e-18
    C1627 (\10\:I1\|net3 \7\:net21) capacitor c=1.27769e-17
    C1628 (net19 \7\:S34) capacitor c=3.05263e-18
    C1629 (\4\:net3 \3\:X0) capacitor c=1.81127e-18
    C1630 (\6\:I3\|N_S vdd!) capacitor c=2.06045e-18
    C1631 (\1\:S20 S21) capacitor c=3.44288e-17
    C1632 (\6\:I1\|net6 \2\:I1\|net6) capacitor c=5.82283e-18
    C1633 (\2\:Y6 \7\:net20) capacitor c=1.00385e-18
    C1634 (net1 \4\:I5\|N_S) capacitor c=1.31637e-18
    C1635 (\3\:S33 vdd!) capacitor c=2.56861e-18
    C1636 (\1\:Y0 I6\|N_S) capacitor c=1.573e-18
    C1637 (\7\:Y7 \4\:Y6) capacitor c=3.40901e-18
    C1638 (I0\|net8 \7\:S12) capacitor c=2.04708e-18
    C1639 (\7\:net1 I0\|net6) capacitor c=4.15329e-18
    C1640 (\6\:I4\|N_S vdd!) capacitor c=2.59388e-18
    C1641 (\21\:vdd! \8\:net3) capacitor c=1.74547e-17
    C1642 (\5\:net22 \3\:I6\|N_S) capacitor c=2.02257e-18
    C1643 (\2\:I0\|N_S02 vdd!) capacitor c=1.14e-18
    C1644 (\8\:I0\|net2 \6\:I0\|net1) capacitor c=1.61512e-17
    C1645 (net17 \3\:I1\|net10) capacitor c=2.34103e-17
    C1646 (\6\:I5\|N_S vdd!) capacitor c=2.00673e-18
    C1647 (\5\:I1\|N_S02 \4\:S13) capacitor c=2.84298e-18
    C1648 (\1\:X5 \4\:I4\|N_S) capacitor c=4.0068e-18
    C1649 (\3\:I0\|net10 \2\:I0\|net10) capacitor c=5.06579e-18
    C1650 (\3\:I0\|N_S10 \7\:S11) capacitor c=2.74844e-17
    C1651 (\7\:I1\|N_S02 \7\:net21) capacitor c=2.22586e-18
    C1652 (\7\:net16 \4\:net15) capacitor c=4.41652e-17
    C1653 (\4\:net1 \2\:I0\|net6) capacitor c=7.00537e-17
    C1654 (\2\:I0\|N_S12 vdd!) capacitor c=1.1362e-18
    C1655 (\2\:net1 \3\:X4) capacitor c=7.39116e-18
    C1656 (\8\:net6 \8\:I0\|net8) capacitor c=2.53982e-17
    C1657 (\3\:net16 \5\:S10) capacitor c=1.1864e-17
    C1658 (\5\:X0 \2\:X1) capacitor c=3.41675e-18
    C1659 (\5\:net16 \4\:I3\|N_S) capacitor c=3.61624e-18
    C1660 (\2\:I1\|N_S02 vdd!) capacitor c=1.14e-18
    C1661 (\9\:I1\|N_S10 I1\|net6) capacitor c=8.82952e-19
    C1662 (\8\:I0\|net2 \7\:S03) capacitor c=1.52113e-18
    C1663 (\6\:I0\|net6 \2\:I0\|N_S10) capacitor c=1.60147e-18
    C1664 (\1\:S22 I1\|N_S01) capacitor c=2.20048e-17
    C1665 (\2\:I1\|N_S12 vdd!) capacitor c=1.1362e-18
    C1666 (\4\:Y4 \5\:net20) capacitor c=2.47225e-17
    C1667 (\5\:I1\|N_S11 \1\:S32) capacitor c=1.2506e-17
    C1668 (\3\:I0\|net5 \4\:I0\|N_S10) capacitor c=2.13128e-18
    C1669 (\6\:X0 \4\:I2\|N_S) capacitor c=9.86023e-19
    C1670 (\6\:S10 \2\:I3\|N_S) capacitor c=1.59114e-17
    C1671 (\158\:gnd! \9\:I3\|N_S) capacitor c=5.83181e-18
    C1672 (\7\:I0\|N_S12 \91\:gnd!) capacitor c=1.13327e-18
    C1673 (\3\:Y1 \2\:I6\|N_S) capacitor c=1.62005e-18
    C1674 (\6\:net16 \2\:I1\|N_S10) capacitor c=6.7902e-18
    C1675 (\7\:S03 vdd!) capacitor c=1.00094e-18
    C1676 (I0\|net6 \4\:S11) capacitor c=6.88084e-18
    C1677 (\2\:X7 \2\:net1) capacitor c=7.87497e-17
    C1678 (\8\:I0\|net5 \7\:S02) capacitor c=1.75744e-18
    C1679 (\5\:net20 I7\|N_S) capacitor c=1.08131e-17
    C1680 (\148\:gnd! \3\:S20) capacitor c=1.58891e-18
    C1681 (\3\:I1\|net10 \2\:I1\|N_S00) capacitor c=2.30726e-18
    C1682 (\7\:I0\|net10 \2\:I0\|net8) capacitor c=1.49431e-16
    C1683 (\2\:X7 \4\:I5\|N_S) capacitor c=8.18971e-19
    C1684 (\1\:Y1 \4\:S04) capacitor c=2.52537e-18
    C1685 (\3\:I1\|net5 \5\:I1\|N_S11) capacitor c=1.94083e-18
    C1686 (\146\:gnd! \9\:I1\|N_S10) capacitor c=7.88827e-18
    C1687 (\4\:net15 \2\:S30) capacitor c=1.57274e-18
    C1688 (\3\:I0\|net9 \2\:I0\|net10) capacitor c=8.88435e-18
    C1689 (\1\:S24 \3\:S14) capacitor c=5.36628e-18
    C1690 (\10\:net16 \1\:S31) capacitor c=1.9572e-18
    C1691 (\2\:Y4 \4\:Y5) capacitor c=7.46977e-19
    C1692 (\6\:net7 \2\:Y5) capacitor c=2.37162e-17
    C1693 (\5\:net1 \2\:I0\|N_S10) capacitor c=2.12277e-18
    C1694 (\3\:S13 \4\:S14) capacitor c=6.13525e-18
    C1695 (\159\:gnd! \3\:S00) capacitor c=1.09249e-18
    C1696 (\109\:vdd! \2\:net7) capacitor c=2.86547e-17
    C1697 (\4\:I0\|net9 \2\:I0\|N_S00) capacitor c=1.31115e-18
    C1698 (\10\:I1\|net8 \8\:I1\|net8) capacitor c=2.62374e-18
    C1699 (\10\:I1\|net3 \5\:I1\|net1) capacitor c=3.60956e-18
    C1700 (\5\:I0\|net1 net7) capacitor c=4.88354e-17
    C1701 (\3\:I0\|net5 \10\:I0\|net10) capacitor c=1.46297e-16
    C1702 (\3\:I0\|net1 \4\:I0\|N_S01) capacitor c=2.04177e-18
    C1703 (\2\:Y0 \2\:I6\|N_S) capacitor c=1.36649e-18
    C1704 (\3\:X4 net3) capacitor c=5.20051e-17
    C1705 (\7\:I1\|N_S00 \37\:vdd!) capacitor c=3.82303e-17
    C1706 (\2\:net15 \49\:gnd!) capacitor c=3.34104e-18
    C1707 (\3\:I1\|net2 \1\:S32) capacitor c=1.1973e-17
    C1708 (\7\:I7\|N_S \6\:Y3) capacitor c=1.04744e-18
    C1709 (\4\:net4 \4\:I0\|N_S00) capacitor c=1.11837e-17
    C1710 (\3\:I0\|N_S02 vdd!) capacitor c=2.39648e-18
    C1711 (\4\:S00 \4\:I2\|N_S) capacitor c=5.24356e-17
    C1712 (X6 \5\:net15) capacitor c=5.6005e-18
    C1713 (\4\:net15 \3\:X6) capacitor c=1.26392e-16
    C1714 (\2\:net7 vdd!) capacitor c=9.77763e-18
    C1715 (\7\:net16 \1\:X7) capacitor c=5.3478e-18
    C1716 (\6\:S14 \3\:S04) capacitor c=3.36813e-18
    C1717 (\5\:X4 X5) capacitor c=7.32982e-19
    C1718 (\8\:I1\|net9 \1\:S22) capacitor c=2.01136e-18
    C1719 (\3\:I1\|net9 net17) capacitor c=1.70512e-18
    C1720 (\3\:I0\|N_S12 vdd!) capacitor c=2.38201e-18
    C1721 (\2\:net5 vdd!) capacitor c=1.10352e-17
    C1722 (\10\:net5 \7\:net20) capacitor c=1.62421e-17
    C1723 (\7\:net19 \10\:I1\|net3) capacitor c=5.48204e-17
    C1724 (\5\:I1\|N_S00 \2\:net17) capacitor c=1.0217e-16
    C1725 (\2\:X5 \4\:net3) capacitor c=1.75191e-17
    C1726 (\3\:I1\|N_S02 vdd!) capacitor c=2.42655e-18
    C1727 (\1\:X4 X5) capacitor c=2.24051e-18
    C1728 (\2\:net8 \2\:Y0) capacitor c=1.80393e-17
    C1729 (\6\:net21 \6\:S24) capacitor c=9.92499e-17
    C1730 (\6\:I0\|N_S11 I0\|net8) capacitor c=1.01605e-18
    C1731 (\4\:net22 \7\:I8\|N_S) capacitor c=1.33969e-17
    C1732 (\3\:S12 \3\:I0\|N_S11) capacitor c=2.71349e-17
    C1733 (\2\:I1\|net10 \3\:S21) capacitor c=1.36466e-17
    C1734 (\6\:I0\|net6 \70\:gnd!) capacitor c=1.69582e-18
    C1735 (\4\:net8 I6\|N_S) capacitor c=1.22357e-18
    C1736 (\3\:I1\|N_S12 vdd!) capacitor c=2.38201e-18
    C1737 (\10\:I1\|net8 \2\:I1\|N_S12) capacitor c=2.1081e-18
    C1738 (\6\:I0\|net2 \3\:S03) capacitor c=1.2925e-18
    C1739 (\1\:S32 I1\|N_S11) capacitor c=2.18406e-17
    C1740 (\2\:I0\|N_S11 \7\:S12) capacitor c=2.74871e-17
    C1741 (\10\:net7 \1\:Y4) capacitor c=2.37737e-17
    C1742 (\8\:I1\|net6 \3\:S32) capacitor c=1.30705e-18
    C1743 (\7\:I1\|net8 \2\:S33) capacitor c=5.57403e-18
    C1744 (\6\:S13 \4\:S03) capacitor c=1.97513e-17
    C1745 (\10\:S22 \1\:Y4) capacitor c=8.01928e-19
    C1746 (\6\:I0\|net5 \2\:I0\|N_S01) capacitor c=2.12764e-18
    C1747 (\3\:Y0 \5\:net22) capacitor c=2.59474e-17
    C1748 (\3\:net5 \3\:S13) capacitor c=2.87194e-18
    C1749 (\5\:I1\|net9 \2\:I1\|N_S01) capacitor c=7.02262e-18
    C1750 (\3\:I0\|net8 \2\:I0\|N_S11) capacitor c=2.30726e-18
    C1751 (\10\:net16 \2\:net15) capacitor c=8.50909e-18
    C1752 (net18 vdd!) capacitor c=2.53758e-18
    C1753 (\10\:I0\|net10 I0\|net8) capacitor c=5.75986e-17
    C1754 (I0\|net6 \2\:net2) capacitor c=1.6223e-16
    C1755 (\8\:net5 \1\:Y6) capacitor c=9.34245e-19
    C1756 (\5\:I1\|net1 \3\:S23) capacitor c=9.22534e-18
    C1757 (\2\:net17 \3\:S11) capacitor c=7.17202e-18
    C1758 (\2\:Y5 \2\:I8\|N_S) capacitor c=1.3767e-18
    C1759 (\7\:net16 \5\:net15) capacitor c=3.06669e-18
    C1760 (net16 vdd!) capacitor c=4.98546e-18
    C1761 (\1\:S34 \3\:S24) capacitor c=5.36628e-18
    C1762 (\4\:net7 Y0) capacitor c=1.0959e-17
    C1763 (\6\:S20 \2\:I4\|N_S) capacitor c=1.59115e-17
    C1764 (\10\:I1\|net6 \2\:I1\|N_S11) capacitor c=2.16954e-18
    C1765 (\6\:net19 \7\:I9\|N_S) capacitor c=1.0444e-16
    C1766 (\3\:X6 \2\:net1) capacitor c=8.88087e-18
    C1767 (\10\:I1\|net10 \2\:I1\|net6) capacitor c=6.87063e-18
    C1768 (\47\:vdd! \5\:S02) capacitor c=6.22788e-18
    C1769 (\2\:I1\|net6 \5\:I1\|net6) capacitor c=2.21953e-18
    C1770 (\7\:net17 vdd!) capacitor c=2.77152e-18
    C1771 (\2\:I1\|net3 I1\|N_S01) capacitor c=1.45311e-18
    C1772 (\8\:I0\|net2 \6\:I0\|net3) capacitor c=7.07745e-17
    C1773 (\2\:Y6 net19) capacitor c=2.48324e-17
    C1774 (\2\:X6 I5\|N_S) capacitor c=3.34654e-18
    C1775 (\3\:I0\|net3 \5\:I0\|net9) capacitor c=1.91879e-17
    C1776 (\2\:I0\|net8 \4\:S13) capacitor c=7.50732e-18
    C1777 (\3\:S02 vdd!) capacitor c=2.63958e-18
    C1778 (net16 \3\:X2) capacitor c=1.05093e-16
    C1779 (\7\:net15 vdd!) capacitor c=2.3524e-18
    C1780 (\1\:Y2 I7\|N_S) capacitor c=1.573e-18
    C1781 (\5\:I0\|net2 I0\|N_S02) capacitor c=8.10805e-18
    C1782 (\5\:I1\|N_S12 \4\:S23) capacitor c=4.97135e-18
    C1783 (\3\:S12 vdd!) capacitor c=2.64437e-18
    C1784 (\3\:I1\|N_S00 \7\:S21) capacitor c=2.72636e-17
    C1785 (\6\:I4\|N_S \2\:net17) capacitor c=1.0061e-17
    C1786 (\5\:I0\|net2 \2\:I0\|N_S02) capacitor c=8.67043e-19
    C1787 (\146\:gnd! \6\:I5\|N_S) capacitor c=1.25911e-18
    C1788 (\6\:net8 \7\:I6\|N_S) capacitor c=3.88465e-17
    C1789 (\2\:net20 \2\:I1\|N_S12) capacitor c=1.02354e-18
    C1790 (\6\:S23 \2\:net5) capacitor c=4.37888e-17
    C1791 (\3\:Y7 \7\:net5) capacitor c=1.23084e-16
    C1792 (\3\:net16 X3) capacitor c=1.19278e-17
    C1793 (\3\:S22 vdd!) capacitor c=2.64437e-18
    C1794 (\9\:I1\|N_S01 I1\|net3) capacitor c=1.86631e-18
    C1795 (\3\:S23 \4\:S24) capacitor c=6.97729e-18
    C1796 (net6 \5\:net20) capacitor c=2.09987e-18
    C1797 (\7\:I1\|net10 \7\:I1\|net6) capacitor c=2.39012e-18
    C1798 (\3\:S32 vdd!) capacitor c=2.64078e-18
    C1799 (\2\:net3 S20) capacitor c=3.73567e-18
    C1800 (\2\:X4 vdd!) capacitor c=3.69195e-18
    C1801 (\2\:net5 \5\:net5) capacitor c=3.68644e-18
    C1802 (net22 \8\:I1\|net2) capacitor c=1.60967e-17
    C1803 (\2\:I0\|N_S01 vdd!) capacitor c=1.14e-18
    C1804 (\3\:Y5 \2\:I8\|N_S) capacitor c=2.67919e-18
    C1805 (\4\:I0\|N_S01 \1\:S02) capacitor c=1.57549e-17
    C1806 (\159\:gnd! \3\:I0\|N_S00) capacitor c=8.64878e-19
    C1807 (\2\:X5 S20) capacitor c=3.86218e-17
    C1808 (\2\:I0\|net3 \6\:I0\|net9) capacitor c=6.0401e-18
    C1809 (\10\:I0\|net8 \7\:S13) capacitor c=1.65619e-18
    C1810 (\8\:I1\|net3 \3\:I1\|N_S12) capacitor c=1.48695e-17
    C1811 (\2\:I0\|N_S11 vdd!) capacitor c=1.14e-18
    C1812 (\6\:net4 vdd!) capacitor c=4.96377e-18
    C1813 (\13\:net5 \2\:Y3) capacitor c=2.69326e-18
    C1814 (\10\:I1\|net3 I1\|N_S12) capacitor c=1.11768e-18
    C1815 (\3\:I1\|net9 \4\:I1\|N_S00) capacitor c=2.42555e-18
    C1816 (\9\:net18 \3\:S11) capacitor c=4.5364e-18
    C1817 (\2\:X5 \5\:S20) capacitor c=1.26646e-17
    C1818 (\8\:net3 \5\:I0\|N_S00) capacitor c=6.61807e-18
    C1819 (\6\:I0\|net3 \3\:S03) capacitor c=9.8324e-19
    C1820 (\4\:net7 \6\:net22) capacitor c=1.18339e-17
    C1821 (\2\:net21 I8\|N_S) capacitor c=1.20964e-17
    C1822 (\8\:net7 \7\:S24) capacitor c=5.24061e-18
    C1823 (\2\:I1\|N_S01 vdd!) capacitor c=1.14e-18
    C1824 (\8\:I0\|net1 \1\:S03) capacitor c=2.05079e-18
    C1825 (I1\|net3 \5\:I1\|N_S01) capacitor c=2.06198e-17
    C1826 (\6\:net4 \2\:S00) capacitor c=8.26844e-19
    C1827 (\7\:I0\|N_S00 \4\:net4) capacitor c=6.69471e-17
    C1828 (\148\:gnd! \3\:I1\|N_S00) capacitor c=8.64203e-19
    C1829 (\8\:net17 \1\:X5) capacitor c=3.25617e-17
    C1830 (\6\:net2 vdd!) capacitor c=2.68666e-18
    C1831 (\3\:I0\|net5 I0\|net10) capacitor c=2.32012e-18
    C1832 (\7\:I0\|N_S12 \4\:S03) capacitor c=4.30958e-18
    C1833 (\4\:net22 \1\:S23) capacitor c=7.51716e-18
    C1834 (\7\:net7 \2\:I8\|N_S) capacitor c=7.87328e-18
    C1835 (\1\:X6 \4\:S30) capacitor c=1.46676e-18
    C1836 (\1\:Y3 \2\:Y3) capacitor c=5.06271e-18
    C1837 (\2\:I1\|N_S11 vdd!) capacitor c=1.14e-18
    C1838 (\2\:net3 vdd!) capacitor c=1.94775e-18
    C1839 (\6\:I1\|net10 \2\:I1\|N_S00) capacitor c=2.40765e-18
    C1840 (\3\:Y6 \7\:S34) capacitor c=2.00343e-18
    C1841 (I1\|net3 \7\:S22) capacitor c=2.04708e-18
    C1842 (\3\:I0\|net2 \4\:I0\|N_S11) capacitor c=2.17161e-18
    C1843 (\1\:S12 \3\:S02) capacitor c=7.08454e-18
    C1844 (\7\:S02 vdd!) capacitor c=1.00094e-18
    C1845 (\2\:Y2 \2\:I7\|N_S) capacitor c=1.42004e-18
    C1846 (\7\:net16 \9\:I1\|N_S10) capacitor c=4.61524e-18
    C1847 (\10\:I0\|net6 \7\:S12) capacitor c=1.73663e-18
    C1848 (I1\|net8 \5\:S32) capacitor c=1.30241e-18
    C1849 (\3\:Y0 \3\:I6\|N_S) capacitor c=3.84995e-18
    C1850 (\8\:I0\|net9 \4\:I0\|N_S01) capacitor c=9.10917e-18
    C1851 (\3\:Y5 \4\:S24) capacitor c=1.78311e-18
    C1852 (\3\:I0\|net2 \5\:I0\|N_S12) capacitor c=1.40219e-18
    C1853 (\6\:net7 \3\:Y5) capacitor c=3.81553e-17
    C1854 (\2\:net7 \5\:S04) capacitor c=3.59751e-18
    C1855 (\5\:I0\|net5 \2\:S02) capacitor c=7.37389e-18
    C1856 (\10\:I1\|net10 \1\:S32) capacitor c=2.01079e-18
    C1857 (\3\:S22 \3\:I1\|N_S01) capacitor c=2.71349e-17
    C1858 (\5\:net17 \5\:S20) capacitor c=1.37263e-17
    C1859 (\5\:I1\|net1 \6\:net21) capacitor c=1.48985e-16
    C1860 (\6\:S30 \2\:I5\|N_S) capacitor c=1.59167e-17
    C1861 (\4\:net20 \3\:I7\|N_S) capacitor c=1.97504e-18
    C1862 (\7\:net1 \22\:vdd!) capacitor c=2.62618e-17
    C1863 (\159\:gnd! \4\:I0\|net9) capacitor c=6.90094e-18
    C1864 (\4\:S10 \4\:I3\|N_S) capacitor c=5.24185e-17
    C1865 (\7\:I1\|net10 \10\:I1\|net6) capacitor c=1.40254e-17
    C1866 (\2\:I1\|N_S01 \7\:S22) capacitor c=2.74354e-17
    C1867 (\10\:I1\|net3 \111\:vdd!) capacitor c=1.34075e-16
    C1868 (\2\:net20 \8\:I1\|net8) capacitor c=1.97452e-17
    C1869 (\9\:I9\|N_S \4\:Y7) capacitor c=8.80902e-19
    C1870 (\3\:I0\|N_S01 vdd!) capacitor c=2.39648e-18
    C1871 (I0\|net10 \4\:I0\|N_S00) capacitor c=2.46544e-18
    C1872 (\6\:net21 \3\:S23) capacitor c=1.26567e-17
    C1873 (\4\:net6 I7\|N_S) capacitor c=1.27365e-18
    C1874 (\7\:net17 \2\:S20) capacitor c=1.4464e-18
    C1875 (\3\:X4 \4\:S20) capacitor c=8.97483e-19
    C1876 (\5\:net20 Y2) capacitor c=4.05878e-17
    C1877 (\6\:S23 \4\:S13) capacitor c=2.21182e-17
    C1878 (\2\:I1\|net6 I1\|N_S10) capacitor c=1.39368e-18
    C1879 (\3\:I0\|N_S11 vdd!) capacitor c=2.39648e-18
    C1880 (\2\:I0\|net6 \2\:net2) capacitor c=6.0401e-18
    C1881 (\4\:I0\|N_S11 \1\:S12) capacitor c=1.54055e-17
    C1882 (\2\:net17 \2\:I0\|net6) capacitor c=1.29763e-17
    C1883 (\1\:X5 \2\:net3) capacitor c=6.26965e-19
    C1884 (\7\:net1 \2\:net2) capacitor c=2.00248e-17
    C1885 (\3\:I1\|N_S01 vdd!) capacitor c=2.39648e-18
    C1886 (\2\:net17 I0\|net6) capacitor c=1.90177e-17
    C1887 (\7\:net7 \4\:Y4) capacitor c=2.66394e-17
    C1888 (I1\|net10 \4\:S21) capacitor c=5.63542e-18
    C1889 (\4\:I0\|net2 \8\:I0\|net6) capacitor c=2.24463e-17
    C1890 (\2\:X3 \6\:net2) capacitor c=8.2951e-17
    C1891 (\4\:net2 \4\:I0\|N_S10) capacitor c=1.12372e-17
    C1892 (\3\:I1\|N_S11 vdd!) capacitor c=2.39648e-18
    C1893 (\2\:Y6 \4\:Y7) capacitor c=9.20205e-19
    C1894 (\6\:net8 I0\|N_S02) capacitor c=4.77172e-18
    C1895 (\13\:net5 \4\:Y2) capacitor c=2.92356e-17
    C1896 (\9\:net18 \4\:I1\|N_S00) capacitor c=1.00567e-17
    C1897 (\3\:S33 \4\:S34) capacitor c=6.14689e-18
    C1898 (\13\:net5 \3\:Y3) capacitor c=4.28876e-18
    C1899 (\6\:I0\|net3 \6\:net6) capacitor c=5.21725e-18
    C1900 (\6\:I1\|net3 \6\:S33) capacitor c=2.03316e-17
    C1901 (\7\:I1\|N_S01 \9\:S22) capacitor c=1.6228e-17
    C1902 (\1\:X1 \4\:S00) capacitor c=2.02157e-18
    C1903 (\10\:I0\|net8 \8\:I0\|net3) capacitor c=2.35261e-17
    C1904 (\7\:I1\|N_S12 \7\:net19) capacitor c=1.83964e-18
    C1905 (\7\:I0\|N_S01 \5\:S02) capacitor c=1.85448e-17
    C1906 (\3\:I0\|net5 \2\:I0\|net10) capacitor c=4.45971e-18
    C1907 (\22\:vdd! \3\:I2\|N_S) capacitor c=1.39848e-18
    C1908 (\4\:net4 \5\:I0\|N_S00) capacitor c=1.09687e-16
    C1909 (\3\:I1\|N_S10 \7\:S31) capacitor c=2.72783e-17
    C1910 (\7\:I1\|N_S02 \2\:S22) capacitor c=3.3469e-18
    C1911 (\9\:I1\|N_S10 \56\:gnd!) capacitor c=2.02946e-17
    C1912 (\1\:Y4 I8\|N_S) capacitor c=1.5464e-18
    C1913 (\3\:I0\|net2 \72\:vdd!) capacitor c=1.83095e-18
    C1914 (\2\:Y7 \2\:I9\|N_S) capacitor c=1.39251e-18
    C1915 (\3\:I0\|net1 \7\:S02) capacitor c=4.65225e-18
    C1916 (\7\:net1 \2\:I0\|N_S10) capacitor c=2.16917e-18
    C1917 (\1\:X7 \4\:I5\|N_S) capacitor c=3.88024e-18
    C1918 (\10\:I0\|net3 \6\:I0\|net2) capacitor c=5.9654e-18
    C1919 (\3\:net7 \3\:S03) capacitor c=7.33975e-18
    C1920 (\13\:net5 \1\:Y3) capacitor c=3.7665e-18
    C1921 (\5\:X2 \2\:X3) capacitor c=3.25435e-18
    C1922 (\3\:I0\|net10 \7\:S01) capacitor c=8.69251e-19
    C1923 (\6\:net21 vdd!) capacitor c=1.42421e-17
    C1924 (\6\:S12 \9\:I0\|N_S01) capacitor c=6.28617e-17
    C1925 (\7\:net7 \2\:Y5) capacitor c=3.08191e-18
    C1926 (\1\:S22 \3\:S12) capacitor c=6.98053e-18
    C1927 (\2\:I0\|net10 \2\:I0\|N_S00) capacitor c=3.90105e-18
    C1928 (\4\:net7 \5\:I6\|N_S) capacitor c=4.1656e-18
    C1929 (\3\:S01 vdd!) capacitor c=2.63958e-18
    C1930 (\7\:I0\|net8 I0\|N_S12) capacitor c=9.01682e-18
    C1931 (\8\:net17 \4\:I4\|N_S) capacitor c=3.61624e-18
    C1932 (\3\:I1\|net6 \2\:I1\|N_S10) capacitor c=2.29759e-18
    C1933 (\35\:gnd! \4\:S01) capacitor c=7.27457e-18
    C1934 (\4\:net3 \5\:I4\|N_S) capacitor c=1.63749e-18
    C1935 (\52\:vdd! \5\:S12) capacitor c=6.2734e-18
    C1936 (net17 \2\:I1\|N_S00) capacitor c=3.99521e-18
    C1937 (\3\:net18 \1\:X1) capacitor c=7.34099e-19
    C1938 (\5\:I2\|N_S \6\:S00) capacitor c=2.20442e-17
    C1939 (\3\:S11 vdd!) capacitor c=2.64437e-18
    C1940 (\6\:net18 \2\:I1\|net10) capacitor c=1.49853e-16
    C1941 (\4\:I0\|net5 \2\:I0\|N_S10) capacitor c=1.01868e-18
    C1942 (\10\:I0\|net3 \1\:S13) capacitor c=2.73686e-18
    C1943 (\2\:net16 S31) capacitor c=5.76442e-18
    C1944 (\5\:I1\|N_S10 \2\:net15) capacitor c=8.88001e-17
    C1945 (\3\:net16 \1\:X3) capacitor c=7.34099e-19
    C1946 (\2\:net4 \2\:I0\|N_S00) capacitor c=8.4409e-19
    C1947 (\7\:I8\|N_S \4\:Y5) capacitor c=1.04744e-18
    C1948 (\3\:S21 vdd!) capacitor c=2.64437e-18
    C1949 (\4\:I1\|N_S01 \1\:S22) capacitor c=1.57549e-17
    C1950 (\4\:net17 \3\:S20) capacitor c=2.98842e-17
    C1951 (\6\:net19 vdd!) capacitor c=1.19186e-17
    C1952 (\8\:net16 \4\:I1\|net5) capacitor c=3.40384e-17
    C1953 (\6\:S34 \3\:S24) capacitor c=2.09122e-18
    C1954 (\3\:S31 vdd!) capacitor c=2.63958e-18
    C1955 (\5\:I1\|N_S11 I1\|net3) capacitor c=1.30176e-17
    C1956 (\8\:I1\|net2 \7\:S23) capacitor c=1.52113e-18
    C1957 (\8\:I0\|net8 \3\:S13) capacitor c=1.31831e-18
    C1958 (\2\:net19 I9\|N_S) capacitor c=1.25352e-17
    C1959 (\2\:net15 \3\:S21) capacitor c=7.40744e-18
    C1960 (\109\:vdd! \1\:S03) capacitor c=9.97642e-19
    C1961 (\7\:I0\|net8 \2\:I0\|N_S12) capacitor c=7.85685e-19
    C1962 (I4\|N_S \1\:S20) capacitor c=9.80229e-17
    C1963 (\3\:I1\|net5 \4\:I1\|N_S10) capacitor c=2.13128e-18
    C1964 (\2\:net1 \1\:S20) capacitor c=7.52089e-18
    C1965 (\2\:I0\|N_S00 vdd!) capacitor c=1.14e-18
    C1966 (\2\:net4 \3\:I0\|net9) capacitor c=9.21662e-18
    C1967 (\3\:Y7 \2\:I9\|N_S) capacitor c=2.57363e-18
    C1968 (\8\:net21 \3\:S23) capacitor c=4.98493e-18
    C1969 (\4\:net15 \4\:I5\|N_S) capacitor c=2.59859e-18
    C1970 (\3\:S32 \3\:I1\|N_S11) capacitor c=2.71196e-17
    C1971 (\3\:I1\|net1 \4\:I1\|N_S01) capacitor c=2.04177e-18
    C1972 (\159\:gnd! \3\:I0\|net10) capacitor c=6.16736e-18
    C1973 (\2\:I0\|N_S10 vdd!) capacitor c=1.14e-18
    C1974 (\4\:Y0 net8) capacitor c=2.70788e-18
    C1975 (\2\:Y4 \2\:I8\|N_S) capacitor c=1.3699e-18
    C1976 (\7\:I1\|net3 \3\:S33) capacitor c=1.05028e-17
    C1977 (\134\:gnd! \6\:S34) capacitor c=1.54529e-17
    C1978 (\2\:I1\|N_S11 \7\:S32) capacitor c=2.74871e-17
    C1979 (\2\:net6 \2\:Y2) capacitor c=1.7451e-17
    C1980 (\10\:I0\|net10 \4\:I0\|N_S11) capacitor c=1.01056e-17
    C1981 (\2\:net19 \7\:net20) capacitor c=6.88637e-18
    C1982 (\4\:I0\|net1 \2\:I0\|N_S01) capacitor c=1.02453e-18
    C1983 (\2\:I1\|N_S00 vdd!) capacitor c=1.14e-18
    C1984 (\13\:net5 \140\:gnd!) capacitor c=7.85059e-17
    C1985 (\8\:I0\|net6 \2\:I0\|N_S11) capacitor c=2.12764e-18
    C1986 (\7\:I1\|net10 \2\:I1\|N_S11) capacitor c=7.22762e-18
    C1987 (\5\:I0\|net1 \2\:I0\|N_S02) capacitor c=6.43776e-18
    C1988 (\3\:I1\|net3 \2\:I1\|N_S01) capacitor c=2.30726e-18
    C1989 (I0\|net3 \3\:I0\|N_S01) capacitor c=6.54913e-18
    C1990 (\10\:I0\|net10 \8\:I0\|net5) capacitor c=7.34128e-17
    C1991 (\4\:net3 \3\:net16) capacitor c=4.94038e-18
    C1992 (\2\:net1 \8\:net2) capacitor c=7.42312e-18
    C1993 (\8\:I1\|net9 I1\|net3) capacitor c=5.79323e-17
    C1994 (\8\:I1\|net5 \3\:I1\|net2) capacitor c=1.60305e-17
    C1995 (\148\:gnd! \7\:net18) capacitor c=1.11338e-17
    C1996 (\2\:I1\|N_S10 vdd!) capacitor c=1.14e-18
    C1997 (\6\:I0\|net1 \6\:net8) capacitor c=7.79604e-18
    C1998 (\10\:I0\|net3 \7\:S03) capacitor c=7.47892e-19
    C1999 (\2\:net7 \9\:I6\|N_S) capacitor c=2.62951e-17
    C2000 (net22 \6\:I1\|net2) capacitor c=2.34585e-17
    C2001 (\4\:S20 \4\:I4\|N_S) capacitor c=5.2476e-17
    C2002 (\8\:I1\|net5 \7\:S22) capacitor c=1.75744e-18
    C2003 (\7\:S01 vdd!) capacitor c=1.00094e-18
    C2004 (\3\:Y7 \4\:S34) capacitor c=2.57426e-18
    C2005 (\6\:I1\|net6 \2\:I1\|N_S10) capacitor c=1.63594e-18
    C2006 (S12 \7\:I0\|N_S01) capacitor c=1.03547e-16
    C2007 (\6\:net22 \1\:S04) capacitor c=3.51703e-18
    C2008 (\7\:I1\|N_S10 \42\:vdd!) capacitor c=3.74651e-17
    C2009 (\6\:S21 \2\:net16) capacitor c=1.4807e-17
    C2010 (\7\:I1\|N_S01 I1\|net3) capacitor c=2.22586e-18
    C2011 (\2\:net1 \5\:I5\|N_S) capacitor c=1.98363e-18
    C2012 (\3\:S03 \2\:I0\|N_S02) capacitor c=5.2461e-17
    C2013 (\10\:net16 \3\:I1\|net5) capacitor c=5.35592e-17
    C2014 (\111\:vdd! \2\:net22) capacitor c=6.03045e-18
    C2015 (\3\:I1\|net5 net15) capacitor c=1.60186e-18
    C2016 (\6\:S33 \4\:S23) capacitor c=1.00119e-17
    C2017 (net18 \3\:I2\|N_S) capacitor c=8.42555e-19
    C2018 (\7\:I1\|N_S02 \4\:S13) capacitor c=2.17188e-18
    C2019 (\3\:Y3 \2\:net6) capacitor c=6.50891e-17
    C2020 (\4\:Y7 \10\:net5) capacitor c=5.69698e-17
    C2021 (\2\:I0\|net8 \5\:I0\|net8) capacitor c=5.03247e-18
    C2022 (\13\:net5 \5\:net20) capacitor c=2.25299e-17
    C2023 (\7\:I0\|net6 \2\:S12) capacitor c=5.47779e-18
    C2024 (\7\:net7 \3\:Y5) capacitor c=1.03345e-16
    C2025 (net15 \3\:I1\|net6) capacitor c=2.26077e-17
    C2026 (\4\:I1\|N_S11 \1\:S32) capacitor c=1.54055e-17
    C2027 (\2\:X7 \5\:S30) capacitor c=1.32114e-17
    C2028 (\1\:S32 \3\:S22) capacitor c=7.08454e-18
    C2029 (\2\:net7 \4\:S04) capacitor c=7.64768e-18
    C2030 (\3\:I0\|N_S00 vdd!) capacitor c=2.35215e-18
    C2031 (I1\|net8 \7\:S32) capacitor c=2.05808e-18
    C2032 (\6\:net6 \7\:I7\|N_S) capacitor c=3.11537e-17
    C2033 (\5\:I3\|N_S \6\:S10) capacitor c=2.21289e-17
    C2034 (\3\:net5 \7\:I0\|net3) capacitor c=1.86394e-17
    C2035 (\4\:net3 S10) capacitor c=6.40487e-18
    C2036 (\8\:net5 \7\:S34) capacitor c=5.17854e-18
    C2037 (I1\|net8 \5\:I1\|N_S11) capacitor c=2.31844e-17
    C2038 (\63\:gnd! \4\:S02) capacitor c=7.40989e-18
    C2039 (\3\:I0\|N_S10 vdd!) capacitor c=2.35215e-18
    C2040 (\6\:net21 I1\|N_S02) capacitor c=1.65977e-18
    C2041 (\3\:X0 \3\:I2\|N_S) capacitor c=1.39397e-17
    C2042 (\2\:Y3 vdd!) capacitor c=7.27989e-18
    C2043 (\5\:net15 \4\:I5\|N_S) capacitor c=1.85704e-18
    C2044 (\9\:I0\|N_S02 \91\:gnd!) capacitor c=2.07346e-17
    C2045 (\6\:net5 \2\:net5) capacitor c=4.24612e-18
    C2046 (\3\:I0\|net3 \2\:I0\|net3) capacitor c=5.06579e-18
    C2047 (\3\:I1\|N_S00 vdd!) capacitor c=2.41925e-18
    C2048 (\2\:net8 \3\:I6\|N_S) capacitor c=1.38093e-17
    C2049 (\8\:net3 net18) capacitor c=6.56542e-18
    C2050 (\6\:net6 I0\|N_S12) capacitor c=3.91252e-18
    C2051 (net18 \9\:I2\|N_S) capacitor c=1.86216e-18
    C2052 (\4\:net2 \3\:S01) capacitor c=3.90257e-18
    C2053 (\3\:I1\|N_S10 vdd!) capacitor c=2.35215e-18
    C2054 (\2\:Y0 \7\:S04) capacitor c=3.82367e-18
    C2055 (\6\:net3 \2\:I0\|N_S00) capacitor c=8.15601e-19
    C2056 (\3\:Y2 \3\:I7\|N_S) capacitor c=3.8235e-18
    C2057 (\2\:Y7 vdd!) capacitor c=1.00279e-17
    C2058 (I0\|net6 \4\:I0\|N_S10) capacitor c=2.48241e-18
    C2059 (\1\:Y6 I9\|N_S) capacitor c=1.89681e-18
    C2060 (\1\:X6 \5\:net15) capacitor c=8.16852e-18
    C2061 (net21 \3\:I8\|N_S) capacitor c=2.02257e-18
    C2062 (\2\:I1\|net6 S32) capacitor c=1.22434e-16
    C2063 (\3\:I0\|net1 \6\:S03) capacitor c=8.84147e-19
    C2064 (\10\:I1\|net8 \3\:net20) capacitor c=1.67208e-17
    C2065 (I0\|net3 \6\:I0\|net9) capacitor c=1.62392e-16
    C2066 (\3\:Y2 \4\:net20) capacitor c=2.40159e-17
    C2067 (\8\:I1\|net1 \1\:S23) capacitor c=2.05079e-18
    C2068 (\7\:net15 \2\:S30) capacitor c=1.50264e-18
    C2069 (\8\:I0\|net5 \3\:I0\|N_S01) capacitor c=9.05074e-19
    C2070 (\2\:Y5 vdd!) capacitor c=8.11415e-18
    C2071 (\10\:I1\|net3 \8\:net21) capacitor c=5.96081e-18
    C2072 (\6\:net3 S12) capacitor c=1.2345e-18
    C2073 (\2\:I1\|net8 I1\|N_S11) capacitor c=1.47506e-18
    C2074 (\4\:net3 \8\:net4) capacitor c=3.6694e-18
    C2075 (\6\:I5\|N_S \2\:net15) capacitor c=1.4266e-17
    C2076 (\111\:vdd! \9\:S22) capacitor c=2.93196e-18
    C2077 (\3\:I0\|net2 \7\:S12) capacitor c=4.66341e-18
    C2078 (\148\:gnd! \6\:I5\|N_S) capacitor c=9.07477e-19
    C2079 (\3\:I0\|net1 \7\:I0\|N_S02) capacitor c=6.3521e-18
    C2080 (\2\:I1\|net6 \3\:S31) capacitor c=1.51852e-17
    C2081 (\5\:I1\|net2 I1\|N_S02) capacitor c=6.74921e-18
    C2082 (I6\|N_S \2\:S04) capacitor c=2.20345e-17
    C2083 (\6\:I0\|N_S11 \5\:S12) capacitor c=1.97264e-17
    C2084 (I1\|net10 \7\:net18) capacitor c=1.65894e-16
    C2085 (\159\:gnd! \9\:I0\|N_S01) capacitor c=8.68438e-19
    C2086 (\2\:net18 \3\:S00) capacitor c=4.78664e-18
    C2087 (\7\:net16 \3\:S31) capacitor c=2.20311e-18
    C2088 (net18 \2\:I2\|N_S) capacitor c=2.4796e-18
    C2089 (\2\:Y2 \2\:Y3) capacitor c=4.89408e-18
    C2090 (\4\:net3 \3\:net18) capacitor c=6.81143e-18
    C2091 (\2\:net1 net3) capacitor c=8.00933e-18
    C2092 (\3\:I0\|N_S01 \7\:S02) capacitor c=2.75014e-17
    C2093 (\1\:Y0 \1\:S04) capacitor c=8.13427e-18
    C2094 (\3\:X6 net1) capacitor c=5.35609e-17
    C2095 (\4\:net7 \2\:S04) capacitor c=2.77834e-18
    C2096 (I1\|net6 \4\:S31) capacitor c=6.73041e-18
    C2097 (net5 \3\:S13) capacitor c=5.0604e-18
    C2098 (\2\:I0\|net10 S12) capacitor c=7.6664e-17
    C2099 (\3\:I1\|net2 \4\:I1\|N_S11) capacitor c=2.17161e-18
    C2100 (\10\:I1\|net8 \7\:S33) capacitor c=1.87409e-18
    C2101 (\3\:I1\|net1 \2\:I1\|net3) capacitor c=8.68166e-18
    C2102 (\3\:I1\|net5 \10\:I1\|net10) capacitor c=1.45848e-16
    C2103 (\8\:I1\|N_S11 I1\|net8) capacitor c=1.4749e-18
    C2104 (\9\:I6\|N_S \119\:gnd!) capacitor c=2.23597e-17
    C2105 (\3\:S13 \2\:I0\|N_S12) capacitor c=5.24761e-17
    C2106 (\2\:Y6 \2\:I9\|N_S) capacitor c=1.34903e-18
    C2107 (\9\:S22 \5\:I1\|net5) capacitor c=1.75037e-18
    C2108 (\7\:I0\|N_S10 \4\:net2) capacitor c=7.3829e-17
    C2109 (\8\:I1\|net9 \4\:I1\|N_S01) capacitor c=9.01994e-18
    C2110 (\57\:vdd! \5\:S22) capacitor c=6.22788e-18
    C2111 (\5\:I4\|N_S \6\:S20) capacitor c=2.21252e-17
    C2112 (\2\:net5 \5\:S14) capacitor c=3.2565e-18
    C2113 (\2\:I1\|net3 \4\:S23) capacitor c=7.61527e-18
    C2114 (\7\:net20 \133\:gnd!) capacitor c=1.02599e-17
    C2115 (\3\:I0\|net8 \7\:I0\|net10) capacitor c=1.91921e-17
    C2116 (\3\:I2\|N_S vdd!) capacitor c=2.27186e-18
    C2117 (\3\:X4 \7\:net17) capacitor c=2.68635e-17
    C2118 (I5\|N_S \1\:S30) capacitor c=9.86006e-17
    C2119 (\148\:gnd! net17) capacitor c=6.89514e-18
    C2120 (\3\:I3\|N_S vdd!) capacitor c=2.24361e-18
    C2121 (I7\|N_S \2\:S14) capacitor c=2.21473e-17
    C2122 (\7\:net16 \8\:net15) capacitor c=9.09029e-18
    C2123 (\2\:Y0 I6\|N_S) capacitor c=6.70303e-19
    C2124 (\4\:net2 \5\:I0\|N_S10) capacitor c=1.11367e-16
    C2125 (\5\:I1\|net2 \2\:I1\|N_S02) capacitor c=8.67043e-19
    C2126 (\4\:S30 \4\:I5\|N_S) capacitor c=5.25404e-17
    C2127 (\5\:net20 \1\:S14) capacitor c=3.38194e-18
    C2128 (\4\:net22 \5\:net20) capacitor c=7.74094e-18
    C2129 (\2\:I1\|net8 \6\:S33) capacitor c=5.99679e-17
    C2130 (\3\:I4\|N_S vdd!) capacitor c=2.28302e-18
    C2131 (\3\:Y1 vdd!) capacitor c=1.47527e-17
    C2132 (\6\:I0\|net6 \8\:I0\|N_S11) capacitor c=3.74551e-18
    C2133 (\2\:Y3 \2\:S14) capacitor c=1.2129e-17
    C2134 (\3\:X6 \4\:S30) capacitor c=9.52205e-19
    C2135 (\8\:I1\|net2 \6\:I1\|net3) capacitor c=7.09376e-17
    C2136 (\3\:I5\|N_S vdd!) capacitor c=2.27186e-18
    C2137 (S11 \4\:S00) capacitor c=7.98415e-18
    C2138 (\10\:I1\|net6 \7\:S32) capacitor c=1.94091e-18
    C2139 (\9\:S22 \3\:S12) capacitor c=3.23041e-18
    C2140 (\9\:S22 \2\:I0\|net8) capacitor c=7.30086e-18
    C2141 (\7\:S00 vdd!) capacitor c=1.28422e-18
    C2142 (\6\:I0\|net1 \3\:S03) capacitor c=9.22978e-19
    C2143 (\6\:Y7 \4\:Y6) capacitor c=5.73155e-18
    C2144 (\134\:gnd! \4\:Y5) capacitor c=2.31275e-18
    C2145 (\2\:net20 \7\:S33) capacitor c=4.84081e-18
    C2146 (\2\:net17 \2\:I1\|net10) capacitor c=7.49863e-17
    C2147 (\2\:Y1 \3\:I6\|N_S) capacitor c=3.38021e-18
    C2148 (\8\:I1\|net2 \6\:I1\|net1) capacitor c=1.61512e-17
    C2149 (\2\:net15 I1\|net10) capacitor c=2.1204e-17
    C2150 (\10\:S22 \6\:net21) capacitor c=7.03131e-18
    C2151 (\1\:X3 \4\:S10) capacitor c=2.02157e-18
    C2152 (I8\|N_S \2\:S24) capacitor c=2.21473e-17
    C2153 (\5\:I1\|net5 \2\:S22) capacitor c=5.63792e-18
    C2154 (\10\:I0\|net8 \3\:I0\|N_S12) capacitor c=9.39587e-19
    C2155 (I0\|net8 \3\:I0\|N_S11) capacitor c=6.85191e-18
    C2156 (\6\:I1\|net2 \3\:S23) capacitor c=1.2925e-18
    C2157 (\3\:Y1 \2\:S04) capacitor c=1.31486e-17
    C2158 (\4\:net3 \8\:net2) capacitor c=1.94153e-18
    C2159 (\2\:X0 net18) capacitor c=5.28245e-17
    C2160 (\4\:net7 \1\:Y0) capacitor c=8.83232e-19
    C2161 (\8\:I0\|net1 \67\:vdd!) capacitor c=2.73669e-18
    C2162 (\5\:net3 \7\:S01) capacitor c=3.30863e-18
    C2163 (\7\:I9\|N_S \4\:Y7) capacitor c=1.04671e-18
    C2164 (\4\:I2\|N_S vdd!) capacitor c=1.24875e-18
    C2165 (\8\:net19 \3\:S33) capacitor c=5.04155e-18
    C2166 (\2\:Y2 \7\:S14) capacitor c=3.38945e-18
    C2167 (net15 \2\:I1\|N_S10) capacitor c=3.90171e-18
    C2168 (\3\:I1\|net2 \5\:I1\|N_S12) capacitor c=1.40219e-18
    C2169 (\10\:I1\|net3 \1\:S33) capacitor c=2.85908e-18
    C2170 (\42\:gnd! \4\:S11) capacitor c=6.83657e-18
    C2171 (\5\:net18 \4\:S00) capacitor c=4.83743e-18
    C2172 (\5\:X4 \2\:X5) capacitor c=3.64476e-18
    C2173 (\8\:I0\|net1 \4\:I0\|N_S02) capacitor c=9.34213e-18
    C2174 (\4\:I1\|net9 \2\:I1\|N_S00) capacitor c=1.31115e-18
    C2175 (\4\:I3\|N_S vdd!) capacitor c=1.24842e-18
    C2176 (\4\:net8 \1\:S04) capacitor c=5.85082e-18
    C2177 (net7 \2\:I0\|N_S02) capacitor c=3.45927e-18
    C2178 (\2\:net2 \2\:I0\|N_S10) capacitor c=8.33232e-19
    C2179 (\7\:I1\|N_S12 \4\:S23) capacitor c=4.30958e-18
    C2180 (\8\:I0\|net5 \4\:I0\|net1) capacitor c=1.86008e-17
    C2181 (\9\:I0\|N_S00 \4\:S01) capacitor c=4.68057e-18
    C2182 (net18 \6\:I2\|N_S) capacitor c=2.21691e-18
    C2183 (\2\:net22 I1\|N_S02) capacitor c=1.94483e-18
    C2184 (\2\:X5 \2\:net3) capacitor c=6.53391e-17
    C2185 (\7\:I0\|net3 \2\:I0\|N_S12) capacitor c=6.92946e-18
    C2186 (\4\:I4\|N_S vdd!) capacitor c=1.15037e-18
    C2187 (\2\:Y1 \4\:net8) capacitor c=5.39576e-17
    C2188 (\6\:net19 \6\:S34) capacitor c=9.30132e-17
    C2189 (\8\:net15 \4\:I5\|N_S) capacitor c=3.61624e-18
    C2190 (\6\:S00 I2\|N_S) capacitor c=1.14218e-17
    C2191 (\4\:I5\|N_S vdd!) capacitor c=1.28231e-18
    C2192 (\5\:I5\|N_S \6\:S30) capacitor c=2.21966e-17
    C2193 (\5\:net15 \5\:S30) capacitor c=1.37054e-17
    C2194 (\6\:I0\|net9 \2\:I0\|N_S01) capacitor c=8.33232e-19
    C2195 (\3\:X0 \2\:X0) capacitor c=1.49668e-18
    C2196 (\3\:I0\|N_S11 \7\:S12) capacitor c=2.74852e-17
    C2197 (\2\:Y1 \2\:net8) capacitor c=1.05053e-16
    C2198 (\4\:I0\|net2 \2\:I0\|N_S11) capacitor c=1.02453e-18
    C2199 (\6\:X4 \4\:I4\|N_S) capacitor c=9.12537e-19
    C2200 (\3\:I0\|net3 \7\:S02) capacitor c=8.69251e-19
    C2201 (\3\:S23 \2\:I1\|N_S02) capacitor c=5.2461e-17
    C2202 (\6\:I1\|net5 \2\:I1\|N_S01) capacitor c=2.12764e-18
    C2203 (\3\:I1\|net8 \2\:I1\|N_S11) capacitor c=2.30498e-18
    C2204 (\4\:S00 vdd!) capacitor c=2.49299e-18
    C2205 (\10\:I1\|net10 I1\|net8) capacitor c=5.75986e-17
    C2206 (\8\:net15 \1\:X7) capacitor c=3.43893e-17
    C2207 (I9\|N_S \2\:S34) capacitor c=2.21473e-17
    C2208 (I0\|net10 \5\:I0\|N_S00) capacitor c=1.69585e-17
    C2209 (\8\:net7 \2\:Y4) capacitor c=1.78374e-17
    C2210 (\2\:net21 \2\:Y5) capacitor c=7.45812e-17
    C2211 (\4\:S10 vdd!) capacitor c=2.49299e-18
    C2212 (\10\:I0\|net6 \3\:I0\|N_S11) capacitor c=9.55551e-19
    C2213 (\4\:net22 \2\:net21) capacitor c=1.01917e-17
    C2214 (net16 \3\:I3\|N_S) capacitor c=3.21365e-18
    C2215 (\9\:S22 \6\:I0\|net6) capacitor c=8.95519e-18
    C2216 (\8\:net3 \6\:S01) capacitor c=2.40069e-18
    C2217 (\4\:S20 vdd!) capacitor c=2.07577e-18
    C2218 (\3\:I1\|net1 \7\:S22) capacitor c=4.65e-18
    C2219 (\7\:I1\|net8 I1\|N_S12) capacitor c=9.15772e-18
    C2220 (\1\:Y2 \1\:S14) capacitor c=5.86464e-18
    C2221 (I0\|net10 \3\:S01) capacitor c=6.72631e-18
    C2222 (\7\:net20 \3\:S34) capacitor c=1.90844e-17
    C2223 (I1\|net10 \4\:I1\|N_S00) capacitor c=2.39606e-18
    C2224 (\4\:S30 vdd!) capacitor c=2.07188e-18
    C2225 (\2\:net18 S21) capacitor c=1.93682e-18
    C2226 (\4\:I1\|net1 \6\:I1\|net5) capacitor c=2.2447e-17
    C2227 (\3\:I0\|net6 \2\:I0\|net6) capacitor c=4.57667e-18
    C2228 (\2\:net1 S21) capacitor c=6.02905e-18
    C2229 (\10\:I1\|net10 \4\:I1\|N_S11) capacitor c=1.01056e-17
    C2230 (\8\:I0\|net5 \5\:I0\|N_S11) capacitor c=9.77412e-18
    C2231 (\5\:I6\|N_S vdd!) capacitor c=4.30874e-18
    C2232 (\2\:net19 \2\:Y7) capacitor c=7.28602e-17
    C2233 (\2\:net6 \3\:I7\|N_S) capacitor c=1.44482e-17
    C2234 (\4\:net1 \2\:I0\|N_S10) capacitor c=8.69347e-19
    C2235 (\4\:net22 \5\:I8\|N_S) capacitor c=4.87012e-18
    C2236 (\5\:I7\|N_S vdd!) capacitor c=4.54515e-18
    C2237 (\2\:net2 \3\:I0\|net5) capacitor c=8.51684e-18
    C2238 (\10\:net16 \4\:I1\|N_S10) capacitor c=1.07029e-17
    C2239 (\7\:I1\|N_S01 \5\:S22) capacitor c=1.84791e-17
    C2240 (\111\:vdd! \6\:S34) capacitor c=4.45563e-18
    C2241 (\5\:X2 S21) capacitor c=1.74346e-18
    C2242 (\3\:Y4 \3\:I8\|N_S) capacitor c=3.84995e-18
    C2243 (\2\:X0 \2\:I2\|N_S) capacitor c=9.4126e-18
    C2244 (\5\:I8\|N_S vdd!) capacitor c=3.25925e-18
    C2245 (\6\:I0\|net10 net4) capacitor c=4.14821e-17
    C2246 (\148\:gnd! \6\:net18) capacitor c=8.48695e-18
    C2247 (\4\:Y0 \6\:net22) capacitor c=7.76643e-18
    C2248 (net8 \4\:Y1) capacitor c=5.13512e-17
    C2249 (\6\:net5 \126\:gnd!) capacitor c=7.13919e-18
    C2250 (\5\:I0\|net2 \1\:S03) capacitor c=2.46568e-18
    C2251 (net19 \3\:I9\|N_S) capacitor c=1.46593e-18
    C2252 (\5\:I1\|net9 \2\:I1\|net3) capacitor c=1.49788e-16
    C2253 (\1\:S04 I6\|N_S) capacitor c=2.17101e-17
    C2254 (\5\:I9\|N_S vdd!) capacitor c=6.31232e-18
    C2255 (\5\:I0\|N_S11 \3\:S02) capacitor c=8.26718e-18
    C2256 (\6\:I1\|N_S11 I1\|net8) capacitor c=1.01425e-18
    C2257 (\2\:net21 \1\:S24) capacitor c=6.16027e-18
    C2258 (\70\:gnd! \4\:S12) capacitor c=6.624e-18
    C2259 (\7\:net21 \3\:S23) capacitor c=7.33975e-18
    C2260 (\9\:I0\|N_S01 \4\:S02) capacitor c=4.7064e-18
    C2261 (\2\:net16 S21) capacitor c=6.97878e-17
    C2262 (\4\:net4 \5\:S01) capacitor c=1.02456e-18
    C2263 (\2\:I0\|net6 \2\:I0\|N_S10) capacitor c=3.42167e-18
    C2264 (\7\:I1\|N_S12 \105\:gnd!) capacitor c=1.13327e-18
    C2265 (\8\:I0\|net9 \3\:I0\|net1) capacitor c=6.68258e-17
    C2266 (\8\:I0\|net3 \6\:net6) capacitor c=7.02213e-18
    C2267 (\6\:net19 \3\:S33) capacitor c=1.51682e-17
    C2268 (net16 \2\:I3\|N_S) capacitor c=2.40163e-18
    C2269 (\62\:vdd! \5\:S32) capacitor c=6.2734e-18
    C2270 (\2\:net17 \6\:S21) capacitor c=5.41714e-17
    C2271 (\1\:X2 S21) capacitor c=5.69676e-18
    C2272 (\3\:I0\|net9 \7\:S01) capacitor c=3.35134e-18
    C2273 (\2\:net1 I3\|N_S) capacitor c=2.35428e-18
    C2274 (\4\:net7 \6\:S04) capacitor c=1.48814e-18
    C2275 (\6\:I2\|N_S \7\:I0\|N_S00) capacitor c=1.5508e-17
    C2276 (\9\:I0\|N_S02 \3\:net7) capacitor c=1.85966e-18
    C2277 (\2\:Y7 \7\:net20) capacitor c=7.19692e-17
    C2278 (\5\:X0 \3\:net18) capacitor c=3.21079e-17
    C2279 (\7\:net1 net16) capacitor c=7.53381e-18
    C2280 (\3\:X2 \3\:I3\|N_S) capacitor c=1.29427e-17
    C2281 (\5\:S00 \5\:I2\|N_S) capacitor c=2.19424e-17
    C2282 (\6\:I1\|net6 \84\:gnd!) capacitor c=2.3825e-18
    C2283 (\6\:I1\|net6 S32) capacitor c=9.45614e-18
    C2284 (\8\:net4 \3\:I2\|N_S) capacitor c=4.82927e-18
    C2285 (\3\:I0\|net1 \3\:I0\|N_S01) capacitor c=1.19074e-18
    C2286 (\3\:I0\|net2 \7\:I0\|N_S12) capacitor c=1.30826e-17
    C2287 (\2\:I1\|net6 \2\:I1\|net10) capacitor c=4.57434e-18
    C2288 (\5\:I0\|N_S02 vdd!) capacitor c=4.40388e-18
    C2289 (\7\:I1\|net8 \2\:I1\|N_S12) capacitor c=7.85504e-19
    C2290 (\10\:I0\|net3 \4\:I0\|N_S12) capacitor c=1.12376e-17
    C2291 (\5\:I0\|N_S12 vdd!) capacitor c=5.22314e-18
    C2292 (\1\:S14 I7\|N_S) capacitor c=2.18141e-17
    C2293 (\3\:S33 \2\:I1\|N_S12) capacitor c=5.25819e-17
    C2294 (\2\:net5 \4\:S14) capacitor c=7.54011e-18
    C2295 (\2\:Y4 \7\:S24) capacitor c=3.82148e-18
    C2296 (\5\:I1\|N_S02 vdd!) capacitor c=4.58236e-18
    C2297 (\7\:net1 \7\:S11) capacitor c=1.76373e-18
    C2298 (\3\:net20 \8\:I1\|net8) capacitor c=1.18925e-17
    C2299 (\6\:S10 I3\|N_S) capacitor c=1.14546e-17
    C2300 (\2\:I0\|net3 \5\:S03) capacitor c=7.40777e-19
    C2301 (\6\:Y3 \3\:I7\|N_S) capacitor c=3.35123e-18
    C2302 (\3\:I1\|N_S01 \7\:S22) capacitor c=2.75014e-17
    C2303 (\4\:net6 \1\:S14) capacitor c=5.70679e-18
    C2304 (\5\:I1\|N_S12 vdd!) capacitor c=5.69901e-18
    C2305 (\21\:vdd! \7\:I0\|N_S00) capacitor c=3.30553e-17
    C2306 (\7\:net5 \2\:net19) capacitor c=2.20333e-18
    C2307 (\3\:I1\|net2 \2\:I1\|net3) capacitor c=3.33161e-18
    C2308 (\7\:I1\|net6 \2\:S32) capacitor c=5.47779e-18
    C2309 (\3\:I1\|net9 \2\:I0\|net6) capacitor c=2.79721e-18
    C2310 (\7\:net20 \2\:S34) capacitor c=4.2283e-18
    C2311 (net20 I1\|N_S12) capacitor c=1.85726e-18
    C2312 (\9\:S22 \2\:I1\|net3) capacitor c=3.85857e-18
    C2313 (\146\:gnd! \2\:net15) capacitor c=2.47383e-18
    C2314 (\8\:I1\|net2 \6\:net21) capacitor c=4.7562e-18
    C2315 (\5\:I1\|net1 \8\:net21) capacitor c=4.88354e-17
    C2316 (\2\:I0\|net3 \3\:S02) capacitor c=1.29418e-17
    C2317 (\6\:S33 vdd!) capacitor c=5.38507e-18
    C2318 (\6\:I4\|N_S \1\:S20) capacitor c=5.83762e-17
    C2319 (\1\:S24 I8\|N_S) capacitor c=2.19632e-17
    C2320 (\3\:I1\|net2 \82\:vdd!) capacitor c=1.83095e-18
    C2321 (I1\|net3 \3\:I1\|N_S01) capacitor c=6.54913e-18
    C2322 (\5\:I0\|net5 I0\|N_S01) capacitor c=7.63291e-18
    C2323 (\4\:net15 \3\:S30) capacitor c=3.97542e-17
    C2324 (\10\:I1\|net10 \8\:I1\|net5) capacitor c=7.34128e-17
    C2325 (\1\:Y4 \1\:S24) capacitor c=7.09112e-18
    C2326 (\5\:I0\|N_S01 vdd!) capacitor c=4.54317e-18
    C2327 (\6\:net19 I1\|N_S12) capacitor c=1.81687e-18
    C2328 (I0\|net8 \8\:I0\|net10) capacitor c=1.61482e-16
    C2329 (\7\:net16 net15) capacitor c=2.63561e-17
    C2330 (\3\:Y3 \7\:S14) capacitor c=2.04645e-18
    C2331 (\2\:net8 \5\:net22) capacitor c=1.30811e-17
    C2332 (\2\:S01 \5\:S02) capacitor c=4.56174e-18
    C2333 (\5\:I0\|N_S11 vdd!) capacitor c=5.36412e-18
    C2334 (\8\:I1\|net5 \3\:I1\|N_S01) capacitor c=9.05074e-19
    C2335 (\2\:net15 \2\:I1\|net10) capacitor c=1.31412e-17
    C2336 (\3\:Y4 net21) capacitor c=2.59474e-17
    C2337 (\7\:net20 \3\:Y7) capacitor c=2.17464e-16
    C2338 (\9\:I0\|N_S12 \98\:gnd!) capacitor c=2.08462e-17
    C2339 (\6\:net8 \1\:S03) capacitor c=1.91949e-17
    C2340 (\2\:I0\|net6 I0\|net8) capacitor c=3.88004e-18
    C2341 (\5\:net15 \6\:X6) capacitor c=6.27293e-17
    C2342 (\4\:I0\|net9 \5\:net3) capacitor c=3.26102e-17
    C2343 (\3\:I1\|net2 \7\:S32) capacitor c=4.66688e-18
    C2344 (\5\:X2 \3\:net16) capacitor c=2.70642e-18
    C2345 (\5\:I1\|N_S01 vdd!) capacitor c=4.53933e-18
    C2346 (\2\:net16 \2\:X3) capacitor c=4.85184e-19
    C2347 (\5\:S10 \5\:I3\|N_S) capacitor c=2.20245e-17
    C2348 (net16 \9\:I3\|N_S) capacitor c=8.79439e-19
    C2349 (\7\:Y7 \10\:net5) capacitor c=4.6936e-18
    C2350 (\4\:net7 \6\:net8) capacitor c=1.57807e-17
    C2351 (\8\:I1\|net8 \3\:S33) capacitor c=1.35955e-18
    C2352 (\5\:I1\|N_S11 vdd!) capacitor c=5.3731e-18
    C2353 (\2\:Y0 \3\:I6\|N_S) capacitor c=2.11099e-18
    C2354 (\2\:I0\|net8 \8\:I0\|net10) capacitor c=6.0401e-18
    C2355 (\2\:net5 \9\:I7\|N_S) capacitor c=2.4356e-17
    C2356 (\5\:I1\|N_S01 \3\:S12) capacitor c=7.78342e-18
    C2357 (\6\:I0\|net2 \2\:I0\|N_S02) capacitor c=2.12764e-18
    C2358 (\5\:I0\|net1 \5\:I0\|net2) capacitor c=2.38184e-18
    C2359 (\7\:I0\|N_S00 I0\|net10) capacitor c=2.21785e-18
    C2360 (\7\:net1 \6\:S11) capacitor c=7.80483e-18
    C2361 (net8 \3\:S04) capacitor c=1.04346e-17
    C2362 (\6\:I0\|net3 \2\:I0\|net3) capacitor c=9.79597e-18
    C2363 (\2\:net19 \1\:S34) capacitor c=6.35043e-18
    C2364 (\4\:net17 \4\:S20) capacitor c=1.34261e-17
    C2365 (\3\:net5 \2\:I0\|N_S12) capacitor c=2.25663e-18
    C2366 (\1\:S34 I9\|N_S) capacitor c=2.20074e-17
    C2367 (I1\|net6 \8\:net16) capacitor c=8.14736e-17
    C2368 (\5\:I0\|net2 \2\:net7) capacitor c=7.18774e-17
    C2369 (\7\:I0\|N_S02 \6\:S03) capacitor c=1.53396e-17
    C2370 (\5\:I1\|net1 \2\:I1\|N_S02) capacitor c=6.43776e-18
    C2371 (\3\:S03 \3\:I0\|N_S02) capacitor c=2.71349e-17
    C2372 (\7\:I0\|net8 \1\:S13) capacitor c=2.41433e-18
    C2373 (I1\|net6 \4\:I1\|N_S10) capacitor c=2.48241e-18
    C2374 (\2\:X7 I5\|N_S) capacitor c=6.13981e-19
    C2375 (\1\:Y1 net8) capacitor c=1.24946e-16
    C2376 (\1\:S10 S11) capacitor c=3.20062e-17
    C2377 (\2\:I0\|N_S02 \7\:S03) capacitor c=2.74713e-17
    C2378 (\6\:S32 vdd!) capacitor c=6.83505e-18
    C2379 (\5\:net1 \7\:S11) capacitor c=2.12277e-18
    C2380 (\10\:I1\|net8 \8\:I1\|net3) capacitor c=2.52464e-17
    C2381 (\6\:Y3 \4\:net6) capacitor c=5.39576e-17
    C2382 (\6\:S32 \5\:S32) capacitor c=1.84455e-18
    C2383 (\6\:I1\|N_S11 \5\:S32) capacitor c=1.92797e-17
    C2384 (\6\:net4 \2\:I2\|N_S) capacitor c=2.78387e-18
    C2385 (\7\:net1 \3\:X0) capacitor c=1.01681e-17
    C2386 (\9\:I7\|N_S \126\:gnd!) capacitor c=2.05952e-17
    C2387 (\5\:I0\|N_S00 vdd!) capacitor c=5.61947e-18
    C2388 (\4\:I0\|net9 \7\:S01) capacitor c=3.16002e-18
    C2389 (\8\:I1\|net1 \4\:I1\|N_S02) capacitor c=9.25289e-18
    C2390 (\8\:I0\|net2 \2\:net7) capacitor c=4.15645e-18
    C2391 (I0\|net6 \3\:S11) capacitor c=6.42537e-18
    C2392 (I0\|net10 \5\:S01) capacitor c=1.44436e-18
    C2393 (\10\:I1\|net3 \6\:I1\|net2) capacitor c=5.8597e-18
    C2394 (\4\:I1\|net5 \2\:I1\|N_S10) capacitor c=1.30147e-18
    C2395 (\2\:I0\|net10 \6\:S12) capacitor c=1.07551e-16
    C2396 (I0\|net6 \5\:I0\|N_S10) capacitor c=2.03219e-17
    C2397 (\1\:X5 \4\:S20) capacitor c=2.02157e-18
    C2398 (\5\:I0\|N_S10 vdd!) capacitor c=7.0005e-18
    C2399 (\7\:net18 \2\:I1\|N_S00) capacitor c=8.4409e-19
    C2400 (\49\:gnd! \4\:S21) capacitor c=7.25137e-18
    C2401 (\8\:I0\|net10 \2\:I0\|N_S11) capacitor c=8.33232e-19
    C2402 (\4\:I1\|net1 \2\:I1\|N_S01) capacitor c=1.02453e-18
    C2403 (\6\:I0\|net5 \7\:S02) capacitor c=2.12764e-18
    C2404 (\8\:I1\|net6 \2\:I1\|N_S11) capacitor c=2.12586e-18
    C2405 (\6\:I1\|net8 S33) capacitor c=9.42882e-18
    C2406 (\5\:I1\|N_S00 vdd!) capacitor c=5.0215e-18
    C2407 (\3\:I1\|N_S11 \7\:S32) capacitor c=2.74852e-17
    C2408 (\9\:I0\|N_S10 \4\:S11) capacitor c=4.77707e-18
    C2409 (\8\:net3 \2\:X0) capacitor c=6.22281e-18
    C2410 (\2\:S11 \5\:S12) capacitor c=4.28989e-18
    C2411 (\7\:net19 \3\:S33) capacitor c=7.30698e-18
    C2412 (\5\:I0\|net5 \2\:I0\|net3) capacitor c=7.08237e-17
    C2413 (\5\:X6 \2\:X7) capacitor c=2.39162e-18
    C2414 (\6\:S20 I4\|N_S) capacitor c=1.24605e-17
    C2415 (\3\:I0\|net5 \7\:S11) capacitor c=4.37891e-18
    C2416 (\5\:I1\|net2 \4\:net22) capacitor c=4.68904e-18
    C2417 (I1\|net10 \9\:net18) capacitor c=5.63948e-17
    C2418 (\2\:X2 \2\:I3\|N_S) capacitor c=7.77849e-18
    C2419 (\5\:net16 \4\:S10) capacitor c=4.61392e-18
    C2420 (\5\:I1\|N_S10 vdd!) capacitor c=7.019e-18
    C2421 (\2\:Y6 \7\:S34) capacitor c=6.46908e-18
    C2422 (\8\:net7 \3\:I8\|N_S) capacitor c=1.38145e-17
    C2423 (\3\:I0\|net2 \3\:I0\|N_S11) capacitor c=1.19074e-18
    C2424 (\4\:I6\|N_S \1\:S04) capacitor c=1.5793e-17
    C2425 (\2\:I1\|net8 \4\:S33) capacitor c=1.78932e-18
    C2426 (\10\:I0\|net6 \4\:I0\|net2) capacitor c=1.82683e-17
    C2427 (\10\:I1\|net8 \3\:I1\|N_S12) capacitor c=1.12224e-18
    C2428 (\7\:net15 \3\:X6) capacitor c=3.3756e-17
    C2429 (\3\:I1\|net3 \5\:I1\|net9) capacitor c=1.91879e-17
    C2430 (\8\:net5 \2\:Y6) capacitor c=2.63162e-17
    C2431 (\3\:Y6 \3\:I9\|N_S) capacitor c=2.96626e-18
    C2432 (\6\:X0 \4\:S00) capacitor c=3.88196e-18
    C2433 (\10\:net7 \1\:S24) capacitor c=2.03674e-18
    C2434 (\3\:S03 \5\:S04) capacitor c=1.23797e-18
    C2435 (\2\:I1\|net10 \7\:net18) capacitor c=5.87398e-18
    C2436 (\10\:I0\|net10 \3\:I0\|net2) capacitor c=6.79875e-17
    C2437 (\108\:vdd! \7\:I6\|N_S) capacitor c=1.15718e-17
    C2438 (\4\:net4 \6\:S01) capacitor c=4.63399e-17
    C2439 (\2\:Y0 \1\:S04) capacitor c=4.60533e-18
    C2440 (\7\:net17 \2\:I4\|N_S) capacitor c=2.45649e-18
    C2441 (\4\:net3 I4\|N_S) capacitor c=2.3765e-18
    C2442 (\7\:net20 \9\:I9\|N_S) capacitor c=7.21326e-17
    C2443 (\3\:I0\|net10 net4) capacitor c=1.90437e-17
    C2444 (\5\:net17 \4\:S20) capacitor c=6.10102e-18
    C2445 (\5\:S20 \5\:I4\|N_S) capacitor c=2.20049e-17
    C2446 (\6\:X6 \4\:I5\|N_S) capacitor c=9.12537e-19
    C2447 (\2\:X2 net16) capacitor c=5.19612e-17
    C2448 (\91\:gnd! \4\:S03) capacitor c=7.32613e-18
    C2449 (\6\:net8 \7\:S03) capacitor c=4.59171e-18
    C2450 (\2\:Y5 \2\:S24) capacitor c=1.33444e-17
    C2451 (\10\:net5 I9\|N_S) capacitor c=1.1387e-18
    C2452 (\6\:Y3 \2\:net6) capacitor c=1.02609e-16
    C2453 (\1\:X1 \8\:net4) capacitor c=3.30936e-17
    C2454 (\9\:net18 \5\:I1\|N_S00) capacitor c=1.9289e-17
    C2455 (net16 \6\:I3\|N_S) capacitor c=1.04699e-18
    C2456 (\4\:Y5 \3\:I8\|N_S) capacitor c=2.99867e-18
    C2457 (\2\:net16 \2\:X5) capacitor c=1.37452e-17
    C2458 (\6\:Y7 Y7) capacitor c=2.95192e-18
    C2459 (\7\:net16 \2\:I1\|N_S10) capacitor c=1.46497e-18
    C2460 (\2\:net15 \6\:S31) capacitor c=5.31255e-17
    C2461 (\2\:I1\|net3 \5\:I1\|net3) capacitor c=3.52123e-18
    C2462 (\4\:net3 \1\:X1) capacitor c=8.3304e-18
    C2463 (\2\:net1 I5\|N_S) capacitor c=6.48768e-18
    C2464 (\7\:net1 \6\:S21) capacitor c=8.34929e-18
    C2465 (\1\:Y6 \1\:S34) capacitor c=1.13042e-17
    C2466 (\3\:I0\|net1 \6\:I0\|net5) capacitor c=1.77925e-18
    C2467 (\4\:I7\|N_S \1\:S14) capacitor c=1.5793e-17
    C2468 (\6\:net19 \6\:net21) capacitor c=1.37351e-17
    C2469 (I0\|net3 \4\:S02) capacitor c=5.73416e-18
    C2470 (\77\:gnd! \4\:S22) capacitor c=7.40989e-18
    C2471 (\8\:I0\|N_S11 \4\:S12) capacitor c=4.8623e-18
    C2472 (\2\:net18 \3\:I2\|N_S) capacitor c=4.50581e-18
    C2473 (\2\:net20 \3\:I1\|N_S12) capacitor c=3.38874e-18
    C2474 (\3\:S13 \3\:I0\|N_S12) capacitor c=2.71349e-17
    C2475 (\2\:S21 \5\:S22) capacitor c=4.11754e-18
    C2476 (I2\|N_S vdd!) capacitor c=5.34502e-18
    C2477 (\6\:net16 \2\:I1\|net6) capacitor c=1.42488e-16
    C2478 (\2\:I0\|net6 \5\:S12) capacitor c=3.1472e-18
    C2479 (\22\:vdd! \6\:net2) capacitor c=4.02255e-18
    C2480 (\3\:I1\|net1 \7\:I1\|N_S02) capacitor c=6.22061e-18
    C2481 (\2\:I0\|N_S12 \7\:S13) capacitor c=2.74458e-17
    C2482 (\7\:I0\|net6 I0\|N_S11) capacitor c=9.67451e-18
    C2483 (\2\:Y2 \3\:I7\|N_S) capacitor c=2.17968e-18
    C2484 (\6\:net6 \1\:S13) capacitor c=1.92437e-17
    C2485 (\7\:net1 \3\:X2) capacitor c=1.28509e-18
    C2486 (\5\:I1\|N_S11 \3\:S22) capacitor c=8.26718e-18
    C2487 (\10\:I1\|net6 \3\:I1\|N_S11) capacitor c=1.12443e-18
    C2488 (I3\|N_S vdd!) capacitor c=4.77761e-18
    C2489 (\4\:net7 \4\:net8) capacitor c=2.50081e-17
    C2490 (\7\:net18 \3\:I1\|net9) capacitor c=1.09794e-17
    C2491 (I4\|N_S vdd!) capacitor c=4.10767e-18
    C2492 (\7\:net16 \6\:X6) capacitor c=2.96599e-18
    C2493 (\3\:I1\|net9 \2\:I1\|net10) capacitor c=8.33823e-18
    C2494 (\6\:I0\|net6 net2) capacitor c=4.3035e-17
    C2495 (\6\:net4 \3\:I2\|N_S) capacitor c=1.05743e-18
    C2496 (\1\:Y0 \4\:I6\|N_S) capacitor c=7.65365e-19
    C2497 (\8\:I0\|net1 \7\:I0\|N_S02) capacitor c=2.24261e-18
    C2498 (\3\:S13 \5\:S14) capacitor c=1.23797e-18
    C2499 (\109\:vdd! \5\:I0\|net2) capacitor c=6.37655e-18
    C2500 (\5\:net20 \5\:I7\|N_S) capacitor c=9.64664e-19
    C2501 (I5\|N_S vdd!) capacitor c=3.81863e-18
    C2502 (\3\:X2 \2\:X2) capacitor c=1.58037e-18
    C2503 (\10\:I1\|net3 \4\:I1\|N_S12) capacitor c=1.1228e-17
    C2504 (\3\:X4 \3\:I4\|N_S) capacitor c=1.34914e-17
    C2505 (I1\|net8 \3\:I1\|N_S11) capacitor c=7.0697e-18
    C2506 (\2\:net1 \2\:net18) capacitor c=2.24848e-16
    C2507 (\4\:I8\|N_S \1\:S24) capacitor c=1.57911e-17
    C2508 (\4\:net2 \35\:gnd!) capacitor c=3.29684e-18
    C2509 (\6\:I0\|net3 \3\:net7) capacitor c=3.86915e-18
    C2510 (\108\:vdd! \2\:Y1) capacitor c=3.99597e-18
    C2511 (\3\:S00 \4\:S01) capacitor c=6.20361e-18
    C2512 (\8\:net2 \3\:I3\|N_S) capacitor c=4.91184e-18
    C2513 (\5\:I1\|net2 \1\:S23) capacitor c=2.36678e-18
    C2514 (\10\:net16 \5\:I1\|N_S10) capacitor c=3.67847e-18
    C2515 (\6\:I1\|net1 \2\:net22) capacitor c=7.87034e-18
    C2516 (\5\:S30 \5\:I5\|N_S) capacitor c=2.20028e-17
    C2517 (\1\:X1 \3\:I2\|N_S) capacitor c=1.99216e-18
    C2518 (net6 \1\:Y3) capacitor c=4.9452e-17
    C2519 (\8\:I0\|net5 \6\:I0\|net9) capacitor c=2.14801e-17
    C2520 (\6\:S30 I5\|N_S) capacitor c=1.24605e-17
    C2521 (net8 \3\:Y1) capacitor c=2.6565e-17
    C2522 (\6\:I3\|N_S \7\:I0\|N_S10) capacitor c=2.91502e-17
    C2523 (\5\:X2 X3) capacitor c=9.18602e-19
    C2524 (\9\:I0\|N_S12 net5) capacitor c=1.86631e-18
    C2525 (\2\:Y2 \1\:S14) capacitor c=4.72656e-18
    C2526 (\8\:I1\|net5 \5\:I1\|N_S11) capacitor c=9.60669e-18
    C2527 (\10\:net5 Y7) capacitor c=3.93683e-18
    C2528 (\4\:net7 \8\:net22) capacitor c=1.70487e-17
    C2529 (\6\:I5\|N_S \1\:S30) capacitor c=5.91619e-17
    C2530 (\4\:I1\|net2 \8\:I1\|net6) capacitor c=2.23607e-17
    C2531 (\7\:net20 \2\:I9\|N_S) capacitor c=2.56136e-18
    C2532 (\4\:Y1 \3\:S04) capacitor c=5.0524e-18
    C2533 (\7\:I1\|net3 \6\:net19) capacitor c=1.49791e-16
    C2534 (\8\:I1\|net3 \2\:net20) capacitor c=2.45166e-17
    C2535 (\6\:S14 \119\:gnd!) capacitor c=7.49528e-18
    C2536 (I0\|net10 \4\:net4) capacitor c=5.35157e-17
    C2537 (\2\:S31 \5\:S32) capacitor c=4.56174e-18
    C2538 (\7\:net1 \2\:X0) capacitor c=1.16086e-18
    C2539 (\9\:I0\|N_S01 \63\:gnd!) capacitor c=2.21682e-17
    C2540 (\2\:net16 \5\:S20) capacitor c=2.61833e-18
    C2541 (\4\:net17 \9\:I1\|N_S00) capacitor c=2.92365e-17
    C2542 (\2\:net16 \2\:X7) capacitor c=1.36115e-17
    C2543 (net6 \3\:S14) capacitor c=1.01545e-17
    C2544 (\4\:I9\|N_S \1\:S34) capacitor c=1.5605e-17
    C2545 (\8\:net8 \2\:I0\|N_S02) capacitor c=1.06791e-18
    C2546 (\4\:net3 \1\:X3) capacitor c=9.05482e-18
    C2547 (\6\:X0 \5\:net18) capacitor c=3.28371e-17
    C2548 (\1\:X2 X3) capacitor c=2.2925e-18
    C2549 (\9\:S22 net5) capacitor c=4.26072e-18
    C2550 (\7\:I0\|N_S12 \6\:S13) capacitor c=1.32724e-17
    C2551 (\8\:I1\|net1 \77\:vdd!) capacitor c=2.60576e-18
    C2552 (\3\:I1\|net1 \3\:I1\|N_S01) capacitor c=1.19074e-18
    C2553 (\3\:I1\|net9 \7\:S21) capacitor c=3.35134e-18
    C2554 (\3\:I0\|net2 \5\:I0\|N_S11) capacitor c=1.76386e-18
    C2555 (\3\:I0\|net8 \2\:I0\|net8) capacitor c=5.12406e-18
    C2556 (\8\:I0\|net8 \2\:I0\|N_S12) capacitor c=2.25471e-18
    C2557 (\3\:net18 \2\:X1) capacitor c=8.78906e-17
    C2558 (\2\:I1\|net10 \2\:I1\|N_S00) capacitor c=4.01726e-18
    C2559 (\2\:Y1 \4\:S04) capacitor c=2.58582e-18
    C2560 (\2\:I0\|net8 \5\:S13) capacitor c=3.22975e-18
    C2561 (\6\:net5 \9\:I7\|N_S) capacitor c=3.96095e-18
    C2562 (\6\:net2 \2\:I3\|N_S) capacitor c=2.60873e-18
    C2563 (\8\:net21 \2\:I1\|N_S02) capacitor c=3.46669e-18
    C2564 (\3\:S23 \3\:I1\|N_S02) capacitor c=2.71349e-17
    C2565 (\5\:I0\|N_S02 \1\:S03) capacitor c=1.18635e-17
    C2566 (\148\:gnd! \2\:net15) capacitor c=1.31795e-17
    C2567 (\7\:I1\|net3 \2\:I1\|N_S12) capacitor c=7.42624e-18
    C2568 (\1\:X7 \2\:net1) capacitor c=1.96459e-18
    C2569 (\2\:I1\|N_S02 \7\:S23) capacitor c=2.74713e-17
    C2570 (\2\:I0\|net6 \3\:I0\|N_S11) capacitor c=1.16406e-18
    C2571 (I1\|net10 \3\:S21) capacitor c=6.35123e-18
    C2572 (\146\:gnd! \5\:I1\|N_S10) capacitor c=1.32423e-18
    C2573 (\4\:net8 \4\:I6\|N_S) capacitor c=1.22162e-17
    C2574 (\4\:net7 \5\:I0\|N_S02) capacitor c=1.80679e-18
    C2575 (\2\:X4 \2\:I4\|N_S) capacitor c=8.33673e-18
    C2576 (\1\:Y7 \2\:Y7) capacitor c=4.02248e-18
    C2577 (\10\:I1\|net3 \3\:I1\|N_S02) capacitor c=1.03114e-18
    C2578 (Y7 \7\:net20) capacitor c=5.25854e-17
    C2579 (\2\:net15 \2\:I1\|net6) capacitor c=7.38808e-17
    C2580 (\10\:I0\|net3 \6\:I0\|net1) capacitor c=1.31482e-17
    C2581 (\4\:Y5 \10\:net7) capacitor c=5.3688e-17
    C2582 (\3\:I0\|net9 \7\:I0\|N_S01) capacitor c=6.34871e-18
    C2583 (\1\:Y1 \7\:S04) capacitor c=2.0355e-18
    C2584 (I1\|net10 \5\:I1\|N_S00) capacitor c=2.06112e-17
    C2585 (\111\:vdd! \5\:I1\|net1) capacitor c=1.23472e-17
    C2586 (\6\:net6 \7\:S13) capacitor c=3.61022e-18
    C2587 (\2\:net16 \3\:S10) capacitor c=3.44046e-18
    C2588 (\4\:Y0 vdd!) capacitor c=6.45125e-19
    C2589 (\4\:Y7 \3\:I9\|N_S) capacitor c=3.3792e-18
    C2590 (\148\:gnd! \1\:S30) capacitor c=1.48581e-18
    C2591 (\6\:I0\|net1 \8\:net8) capacitor c=5.40092e-17
    C2592 (\7\:net15 \3\:I5\|N_S) capacitor c=9.04477e-19
    C2593 (\140\:gnd! \4\:Y2) capacitor c=2.09165e-17
    C2594 (\8\:I1\|net9 \3\:I1\|net1) capacitor c=6.66688e-17
    C2595 (\2\:Y4 \3\:I8\|N_S) capacitor c=2.10782e-18
    C2596 (\4\:net3 \2\:net18) capacitor c=4.5007e-18
    C2597 (\8\:net5 \3\:I9\|N_S) capacitor c=1.39649e-17
    C2598 (\3\:net16 \2\:X3) capacitor c=7.69811e-17
    C2599 (\7\:net15 \2\:I5\|N_S) capacitor c=2.4796e-18
    C2600 (I0\|N_S00 \2\:S01) capacitor c=2.2087e-17
    C2601 (net17 \7\:S21) capacitor c=3.30863e-18
    C2602 (\9\:I3\|N_S \9\:I0\|N_S10) capacitor c=1.22544e-17
    C2603 (\2\:net1 \4\:net17) capacitor c=4.66805e-18
    C2604 (\6\:I1\|net9 \2\:I1\|N_S01) capacitor c=8.33232e-19
    C2605 (\13\:net5 \4\:net6) capacitor c=3.51257e-18
    C2606 (\4\:I1\|net2 \2\:I1\|N_S11) capacitor c=1.0207e-18
    C2607 (\8\:I0\|net6 \7\:S12) capacitor c=2.12764e-18
    C2608 (\4\:I0\|net1 \7\:S02) capacitor c=3.05594e-18
    C2609 (\6\:net8 \6\:S04) capacitor c=3.41243e-17
    C2610 (\4\:I0\|net5 \7\:S11) capacitor c=3.05883e-18
    C2611 (I1\|net3 \6\:I1\|net9) capacitor c=1.62392e-16
    C2612 (\7\:I0\|N_S02 \67\:vdd!) capacitor c=3.70257e-17
    C2613 (\2\:net22 \1\:S23) capacitor c=8.01959e-18
    C2614 (\8\:net22 \12\:net5) capacitor c=2.27192e-18
    C2615 (\2\:net4 \7\:S01) capacitor c=4.69246e-18
    C2616 (\7\:I1\|net3 \8\:net19) capacitor c=5.01483e-17
    C2617 (\7\:I0\|N_S10 I0\|net6) capacitor c=9.64957e-19
    C2618 (\2\:Y4 \2\:Y5) capacitor c=1.32688e-17
    C2619 (\4\:net2 \6\:S11) capacitor c=5.78816e-17
    C2620 (\2\:net6 \4\:net20) capacitor c=1.30811e-17
    C2621 (\2\:Y7 \2\:S34) capacitor c=1.55905e-17
    C2622 (\8\:I0\|net9 \47\:vdd!) capacitor c=2.73669e-18
    C2623 (\5\:I1\|net5 I1\|N_S01) capacitor c=8.8334e-18
    C2624 (\3\:Y6 net19) capacitor c=2.03873e-17
    C2625 (\3\:I0\|net9 \3\:I0\|N_S00) capacitor c=1.17146e-18
    C2626 (\56\:gnd! \4\:S31) capacitor c=7.35479e-18
    C2627 (\2\:Y4 \1\:S24) capacitor c=4.29006e-18
    C2628 (\3\:S10 \4\:S11) capacitor c=7.51754e-18
    C2629 (\7\:net16 I1\|net6) capacitor c=8.92998e-17
    C2630 (\5\:X0 \1\:X1) capacitor c=2.51948e-17
    C2631 (\7\:net1 \2\:X2) capacitor c=1.06867e-18
    C2632 (\6\:I1\|net6 \8\:I1\|N_S11) capacitor c=4.77475e-18
    C2633 (\9\:I0\|N_S02 \4\:S03) capacitor c=4.68057e-18
    C2634 (\9\:I1\|N_S00 \4\:S21) capacitor c=4.68057e-18
    C2635 (\3\:S33 \5\:S34) capacitor c=1.16424e-18
    C2636 (I0\|net8 \4\:S12) capacitor c=6.18768e-18
    C2637 (\2\:I0\|net8 \3\:S12) capacitor c=1.38919e-17
    C2638 (\1\:X7 \4\:S30) capacitor c=2.02157e-18
    C2639 (\98\:gnd! \4\:S13) capacitor c=6.70922e-18
    C2640 (\2\:net16 \5\:S30) capacitor c=2.60861e-18
    C2641 (\2\:net16 \3\:X2) capacitor c=5.82178e-17
    C2642 (\7\:I1\|net8 \1\:S33) capacitor c=2.90556e-18
    C2643 (\12\:net5 S22) capacitor c=5.37873e-18
    C2644 (\6\:net22 \3\:Y1) capacitor c=9.84149e-17
    C2645 (\8\:net17 \4\:S20) capacitor c=4.65067e-18
    C2646 (\9\:I1\|N_S02 \105\:gnd!) capacitor c=2.0787e-17
    C2647 (\4\:net17 \7\:I1\|N_S00) capacitor c=4.59914e-17
    C2648 (\2\:S13 \3\:S03) capacitor c=5.67684e-18
    C2649 (\8\:net22 S22) capacitor c=2.11294e-18
    C2650 (\7\:net17 \9\:I4\|N_S) capacitor c=1.62939e-18
    C2651 (\2\:Y0 vdd!) capacitor c=2.61258e-18
    C2652 (\9\:S22 \6\:I0\|net8) capacitor c=3.20261e-17
    C2653 (\5\:I0\|N_S12 \1\:S13) capacitor c=9.47459e-18
    C2654 (\5\:I8\|N_S \2\:net21) capacitor c=8.23297e-17
    C2655 (\7\:net1 \3\:I0\|N_S10) capacitor c=9.53422e-19
    C2656 (\6\:S32 \2\:S31) capacitor c=2.99913e-18
    C2657 (\6\:X2 \4\:S10) capacitor c=1.95221e-18
    C2658 (\3\:S33 \3\:I1\|N_S12) capacitor c=2.71196e-17
    C2659 (\8\:I1\|net5 \4\:I1\|net1) capacitor c=1.86008e-17
    C2660 (\4\:net2 I0\|net10) capacitor c=1.8813e-17
    C2661 (\2\:I1\|N_S12 \7\:S33) capacitor c=2.74492e-17
    C2662 (\6\:S11 \4\:S01) capacitor c=1.4699e-17
    C2663 (\6\:I0\|net10 \4\:net1) capacitor c=5.85971e-18
    C2664 (\2\:Y4 vdd!) capacitor c=3.50165e-18
    C2665 (I0\|N_S10 \2\:S11) capacitor c=2.1962e-17
    C2666 (\3\:net18 \5\:net18) capacitor c=5.12406e-18
    C2667 (\2\:Y1 \4\:I6\|N_S) capacitor c=2.48241e-18
    C2668 (\8\:I0\|net9 \5\:I0\|N_S01) capacitor c=1.26194e-17
    C2669 (\6\:net3 \2\:S01) capacitor c=3.3668e-18
    C2670 (\3\:net16 \5\:net16) capacitor c=5.12406e-18
    C2671 (\4\:I0\|net5 \5\:net1) capacitor c=2.22476e-17
    C2672 (\84\:gnd! \4\:S32) capacitor c=7.4218e-18
    C2673 (\21\:vdd! \6\:I2\|N_S) capacitor c=3.96735e-17
    C2674 (\3\:I1\|net2 \7\:I1\|N_S12) capacitor c=8.77209e-18
    C2675 (\9\:I1\|N_S01 \4\:S22) capacitor c=4.92116e-18
    C2676 (\9\:I8\|N_S \137\:gnd!) capacitor c=2.23597e-17
    C2677 (\4\:Y5 \8\:net7) capacitor c=1.04068e-16
    C2678 (\6\:net8 \5\:I0\|net2) capacitor c=8.49515e-17
    C2679 (\6\:net2 \3\:I3\|N_S) capacitor c=1.05743e-18
    C2680 (\3\:I1\|net5 \2\:I1\|net10) capacitor c=2.34333e-18
    C2681 (\7\:net1 \2\:net18) capacitor c=1.46583e-16
    C2682 (\2\:Y6 \2\:Y7) capacitor c=1.54035e-18
    C2683 (\3\:I1\|net2 \3\:I1\|N_S11) capacitor c=1.19074e-18
    C2684 (\2\:net18 \5\:X0) capacitor c=7.20795e-17
    C2685 (\4\:net3 \2\:net1) capacitor c=2.80929e-16
    C2686 (\7\:I0\|net8 \2\:net5) capacitor c=6.82542e-17
    C2687 (\2\:Y4 \3\:Y5) capacitor c=8.22234e-19
    C2688 (\5\:net22 \3\:S04) capacitor c=2.02157e-18
    C2689 (\3\:I0\|net2 \8\:I0\|net6) capacitor c=1.77925e-18
    C2690 (S12 \6\:S02) capacitor c=8.38866e-18
    C2691 (\2\:X4 \7\:net17) capacitor c=5.24097e-17
    C2692 (\3\:net18 \4\:I2\|N_S) capacitor c=2.0214e-18
    C2693 (\3\:I1\|net5 \7\:S31) capacitor c=4.37891e-18
    C2694 (\4\:net6 \4\:I7\|N_S) capacitor c=1.12597e-17
    C2695 (\7\:net16 \4\:I1\|net5) capacitor c=2.23439e-17
    C2696 (\7\:net17 \6\:I4\|N_S) capacitor c=2.21691e-18
    C2697 (\6\:Y3 \4\:S14) capacitor c=2.74256e-18
    C2698 (\7\:net16 \4\:S30) capacitor c=1.27693e-18
    C2699 (\1\:Y3 \3\:S14) capacitor c=5.01497e-18
    C2700 (X4 \5\:net17) capacitor c=5.86521e-18
    C2701 (\148\:gnd! \5\:I1\|N_S10) capacitor c=5.83864e-18
    C2702 (I1\|net10 \5\:S21) capacitor c=1.44477e-18
    C2703 (\2\:Y6 \3\:I9\|N_S) capacitor c=3.40519e-18
    C2704 (\2\:S23 \3\:S13) capacitor c=5.67684e-18
    C2705 (\6\:net7 \3\:S24) capacitor c=3.87322e-18
    C2706 (\3\:X0 \7\:S00) capacitor c=4.89603e-18
    C2707 (\159\:gnd! \1\:S10) capacitor c=1.47271e-18
    C2708 (\3\:I1\|net8 \7\:I1\|net10) capacitor c=1.91105e-17
    C2709 (\7\:net1 \1\:S10) capacitor c=4.85088e-18
    C2710 (\4\:net7 \1\:S04) capacitor c=1.88444e-18
    C2711 (\7\:I1\|N_S02 \6\:S23) capacitor c=2.44623e-17
    C2712 (\4\:net17 \3\:I4\|N_S) capacitor c=5.16249e-18
    C2713 (\2\:Y0 \4\:I6\|N_S) capacitor c=1.66047e-18
    C2714 (\3\:X6 \3\:I5\|N_S) capacitor c=1.39069e-17
    C2715 (\2\:net7 \2\:S03) capacitor c=1.22353e-17
    C2716 (\2\:net3 \2\:I4\|N_S) capacitor c=2.05956e-18
    C2717 (\2\:I1\|net10 \5\:S22) capacitor c=3.17954e-18
    C2718 (\6\:I0\|net1 \2\:I0\|N_S02) capacitor c=8.09368e-19
    C2719 (I1\|N_S00 \2\:S21) capacitor c=2.21859e-17
    C2720 (\1\:Y4 \4\:I8\|N_S) capacitor c=7.19841e-19
    C2721 (\158\:gnd! \6\:I3\|N_S) capacitor c=3.22426e-18
    C2722 (\6\:I1\|net10 \6\:net18) capacitor c=4.14821e-17
    C2723 (\3\:Y5 \7\:S24) capacitor c=2.04113e-18
    C2724 (\3\:I1\|net10 \2\:I1\|net10) capacitor c=5.12406e-18
    C2725 (net3 \3\:I4\|N_S) capacitor c=4.90271e-18
    C2726 (\6\:I0\|net8 \2\:I0\|net8) capacitor c=4.89507e-18
    C2727 (\3\:S20 \4\:S21) capacitor c=6.4993e-18
    C2728 (\6\:net21 \6\:I1\|net1) capacitor c=5.64078e-18
    C2729 (\8\:net16 \3\:I1\|net5) capacitor c=6.77547e-18
    C2730 (\10\:I1\|net8 \4\:S33) capacitor c=2.21792e-18
    C2731 (\7\:net1 \6\:I0\|net6) capacitor c=2.45379e-17
    C2732 (\8\:net6 \2\:I0\|N_S12) capacitor c=1.09131e-18
    C2733 (\4\:Y2 net6) capacitor c=2.00833e-18
    C2734 (\10\:net5 \1\:S34) capacitor c=2.95279e-18
    C2735 (\2\:net22 \7\:S23) capacitor c=4.5957e-18
    C2736 (\5\:I1\|N_S02 \1\:S23) capacitor c=1.20863e-17
    C2737 (\1\:X3 \3\:I3\|N_S) capacitor c=1.82906e-18
    C2738 (\3\:Y7 \8\:net5) capacitor c=6.53693e-17
    C2739 (net20 \1\:S33) capacitor c=1.16707e-17
    C2740 (\4\:net15 \4\:S30) capacitor c=1.90894e-17
    C2741 (\1\:S20 \2\:net17) capacitor c=1.33467e-17
    C2742 (\6\:I1\|net2 \2\:I1\|N_S02) capacitor c=2.12764e-18
    C2743 (\3\:I0\|net6 net2) capacitor c=1.91921e-17
    C2744 (I1\|net6 \3\:S31) capacitor c=7.29551e-18
    C2745 (\2\:X6 \2\:I5\|N_S) capacitor c=7.76256e-18
    C2746 (\108\:vdd! \7\:I7\|N_S) capacitor c=9.06016e-19
    C2747 (\8\:net19 \2\:I1\|N_S12) capacitor c=3.37049e-18
    C2748 (\7\:I1\|net10 \2\:I1\|net8) capacitor c=1.50436e-16
    C2749 (\4\:Y6 \7\:net5) capacitor c=2.95961e-18
    C2750 (\5\:net17 \1\:X5) capacitor c=7.32512e-19
    C2751 (\10\:I0\|net6 \8\:I0\|net10) capacitor c=2.00903e-17
    C2752 (net7 \7\:S03) capacitor c=1.06478e-18
    C2753 (\158\:gnd! \5\:I0\|N_S10) capacitor c=1.32423e-18
    C2754 (\3\:I0\|N_S02 \7\:S03) capacitor c=2.73822e-17
    C2755 (\3\:I0\|net1 \5\:I0\|net5) capacitor c=7.70447e-17
    C2756 (\4\:net22 vdd!) capacitor c=7.6879e-18
    C2757 (\8\:net3 \6\:net4) capacitor c=2.70546e-17
    C2758 (\7\:I1\|net6 I1\|N_S11) capacitor c=9.67451e-18
    C2759 (\2\:Y6 \3\:Y7) capacitor c=1.07479e-18
    C2760 (\10\:I1\|net10 \3\:I1\|net2) capacitor c=6.79875e-17
    C2761 (\6\:net2 S10) capacitor c=3.12843e-17
    C2762 (\3\:I0\|net5 \3\:I0\|N_S10) capacitor c=1.15086e-18
    C2763 (\2\:X0 \6\:S00) capacitor c=2.05962e-18
    C2764 (\6\:net8 \4\:I0\|N_S02) capacitor c=2.78373e-18
    C2765 (\6\:net21 \2\:I1\|N_S02) capacitor c=3.05419e-18
    C2766 (\2\:S03 \5\:S04) capacitor c=4.81518e-18
    C2767 (\2\:Y0 \1\:Y1) capacitor c=8.52387e-19
    C2768 (\6\:S14 \4\:S04) capacitor c=2.09654e-17
    C2769 (\6\:net6 \6\:S14) capacitor c=4.08353e-17
    C2770 (I1\|net6 \5\:I1\|N_S10) capacitor c=2.45645e-17
    C2771 (\1\:X3 \8\:net2) capacitor c=3.30888e-17
    C2772 (I0\|net6 \4\:net2) capacitor c=5.37252e-17
    C2773 (\2\:X3 S10) capacitor c=2.28148e-17
    C2774 (\9\:I1\|N_S02 \7\:net21) capacitor c=1.86631e-18
    C2775 (net8 \5\:net22) capacitor c=1.29254e-17
    C2776 (\6\:I0\|net8 \98\:gnd!) capacitor c=1.59168e-18
    C2777 (\2\:S33 \3\:S23) capacitor c=7.57412e-18
    C2778 (\5\:I0\|net5 \1\:S02) capacitor c=2.97785e-18
    C2779 (\1\:Y5 \6\:net7) capacitor c=3.27516e-17
    C2780 (\6\:Y3 \4\:I7\|N_S) capacitor c=2.48241e-18
    C2781 (\6\:S21 \4\:S11) capacitor c=2.35917e-17
    C2782 (\3\:I0\|net5 \6\:I0\|N_S11) capacitor c=9.49451e-18
    C2783 (I1\|N_S10 \2\:S31) capacitor c=2.19661e-17
    C2784 (I1\|net3 \4\:S22) capacitor c=5.78115e-18
    C2785 (\9\:net18 \6\:S21) capacitor c=2.66415e-17
    C2786 (\3\:Y5 \8\:net7) capacitor c=5.74761e-17
    C2787 (\8\:I0\|net1 vdd!) capacitor c=6.02367e-18
    C2788 (\7\:I6\|N_S \87\:vdd!) capacitor c=3.79344e-17
    C2789 (\2\:I0\|net6 \6\:I0\|N_S11) capacitor c=3.11904e-17
    C2790 (\4\:net15 I1\|net6) capacitor c=2.8421e-18
    C2791 (\4\:Y2 \5\:net20) capacitor c=7.21978e-17
    C2792 (\5\:net15 \4\:S30) capacitor c=6.07775e-18
    C2793 (\2\:net1 \3\:I5\|N_S) capacitor c=1.30057e-18
    C2794 (\10\:I0\|net3 vdd!) capacitor c=4.46701e-18
    C2795 (\3\:net7 \7\:S03) capacitor c=2.04708e-18
    C2796 (\6\:Y7 \10\:net5) capacitor c=2.51625e-18
    C2797 (\6\:I1\|net5 \7\:S22) capacitor c=2.12764e-18
    C2798 (\5\:net3 \3\:I0\|N_S00) capacitor c=1.99781e-18
    C2799 (\6\:I0\|net9 \7\:S02) capacitor c=4.94547e-18
    C2800 (\4\:I0\|net2 \7\:S12) capacitor c=3.0564e-18
    C2801 (\7\:net16 \7\:S31) capacitor c=3.87523e-18
    C2802 (\3\:net16 \4\:I3\|N_S) capacitor c=1.74639e-18
    C2803 (\3\:I0\|net9 \5\:S02) capacitor c=7.84859e-19
    C2804 (\8\:I1\|net1 vdd!) capacitor c=6.14802e-17
    C2805 (\5\:I9\|N_S \2\:net19) capacitor c=8.16441e-17
    C2806 (\10\:I1\|net6 \4\:S32) capacitor c=2.21658e-18
    C2807 (\2\:I1\|net3 \5\:S23) capacitor c=3.17954e-18
    C2808 (\10\:I0\|net10 \5\:I0\|N_S11) capacitor c=1.02724e-17
    C2809 (net15 \7\:S31) capacitor c=3.30208e-18
    C2810 (\10\:I1\|net3 vdd!) capacitor c=1.07963e-17
    C2811 (\2\:S13 \5\:S14) capacitor c=4.80927e-18
    C2812 (\10\:net7 \4\:I8\|N_S) capacitor c=1.09181e-17
    C2813 (\27\:vdd! \5\:S01) capacitor c=6.31164e-18
    C2814 (\10\:I0\|net10 \52\:vdd!) capacitor c=3.53067e-18
    C2815 (\4\:net1 \2\:S11) capacitor c=5.41268e-18
    C2816 (\159\:gnd! \5\:I0\|N_S10) capacitor c=5.62653e-18
    C2817 (\4\:I1\|net9 \7\:S21) capacitor c=3.16002e-18
    C2818 (\6\:I0\|net10 \3\:I0\|net5) capacitor c=7.13576e-17
    C2819 (\9\:I0\|N_S12 \4\:S13) capacitor c=4.89505e-18
    C2820 (\2\:Y2 \4\:I7\|N_S) capacitor c=1.66047e-18
    C2821 (\2\:net2 \7\:S11) capacitor c=4.94167e-18
    C2822 (\4\:net8 \5\:I6\|N_S) capacitor c=1.16076e-16
    C2823 (\105\:gnd! \4\:S23) capacitor c=7.32613e-18
    C2824 (\4\:net3 \5\:net18) capacitor c=3.4528e-18
    C2825 (\5\:I1\|N_S12 \1\:S33) capacitor c=1.02318e-17
    C2826 (\7\:I0\|N_S12 \72\:vdd!) capacitor c=3.94487e-17
    C2827 (\10\:S22 \6\:net5) capacitor c=5.24896e-17
    C2828 (\7\:I0\|net6 \2\:I0\|net8) capacitor c=7.1894e-17
    C2829 (\6\:I0\|net9 \4\:I0\|net1) capacitor c=5.17378e-17
    C2830 (\4\:net22 \10\:net7) capacitor c=5.34543e-18
    C2831 (\2\:net18 \7\:S00) capacitor c=2.03828e-18
    C2832 (\3\:S01 \5\:S02) capacitor c=1.17478e-18
    C2833 (\108\:vdd! \9\:I6\|N_S) capacitor c=2.6283e-18
    C2834 (\8\:I0\|net2 \5\:I0\|N_S12) capacitor c=7.76078e-18
    C2835 (\2\:Y0 \3\:Y1) capacitor c=7.96889e-18
    C2836 (\9\:I1\|N_S10 \4\:S31) capacitor c=4.5915e-18
    C2837 (\3\:I0\|N_S12 \7\:S13) capacitor c=2.74852e-17
    C2838 (\8\:I0\|N_S11 \70\:gnd!) capacitor c=2.07071e-17
    C2839 (\3\:S30 \4\:S31) capacitor c=6.62049e-18
    C2840 (\1\:Y6 \4\:I9\|N_S) capacitor c=2.16119e-18
    C2841 (\109\:vdd! \7\:I7\|N_S) capacitor c=3.71379e-18
    C2842 (\109\:vdd! \3\:S03) capacitor c=1.40335e-18
    C2843 (\3\:I1\|net2 \5\:I1\|N_S11) capacitor c=1.26475e-18
    C2844 (\5\:I0\|net1 \2\:net7) capacitor c=1.48914e-16
    C2845 (\10\:I0\|net8 \6\:net6) capacitor c=2.30054e-18
    C2846 (\2\:I1\|net6 \2\:I1\|N_S10) capacitor c=3.44852e-18
    C2847 (\2\:net5 \6\:Y3) capacitor c=2.47978e-18
    C2848 (\6\:net8 \3\:I0\|N_S02) capacitor c=1.05377e-18
    C2849 (\159\:gnd! \6\:I3\|N_S) capacitor c=1.11989e-18
    C2850 (\4\:net3 \7\:net1) capacitor c=2.16208e-17
    C2851 (\5\:I1\|net1 \5\:I1\|net2) capacitor c=2.38184e-18
    C2852 (\5\:I1\|N_S02 \4\:net22) capacitor c=1.00734e-17
    C2853 (\1\:S01 I0\|N_S00) capacitor c=2.17683e-17
    C2854 (\7\:I1\|N_S00 I1\|net10) capacitor c=2.21785e-18
    C2855 (\2\:S23 \5\:S24) capacitor c=4.64723e-18
    C2856 (\3\:Y7 \7\:S34) capacitor c=2.0355e-18
    C2857 (\4\:net20 \3\:S14) capacitor c=1.97404e-18
    C2858 (\6\:net5 \7\:I0\|net3) capacitor c=3.95131e-17
    C2859 (\3\:X0 \6\:net4) capacitor c=6.84533e-18
    C2860 (\2\:I1\|net3 \6\:I1\|net9) capacitor c=6.0401e-18
    C2861 (\2\:net3 \3\:I4\|N_S) capacitor c=1.06656e-18
    C2862 (I1\|net6 \5\:S31) capacitor c=1.36098e-18
    C2863 (\8\:I1\|net1 \7\:I1\|N_S02) capacitor c=9.84562e-19
    C2864 (\86\:vdd! \2\:Y1) capacitor c=4.61828e-17
    C2865 (\123\:gnd! \71\:vdd!) capacitor c=1.60717e-17
    C2866 (\10\:gnd! \9\:I3\|N_S) capacitor c=2.06396e-17
    C2867 (\4\:gnd! \6\:I3\|N_S) capacitor c=1.6024e-18
    C2868 (\76\:gnd! \6\:S32) capacitor c=2.0055e-17
    C2869 (\10\:I1\|net3 \81\:vdd!) capacitor c=5.09385e-17
    C2870 (\34\:gnd! \7\:I0\|N_S10) capacitor c=1.29567e-18
    C2871 (\7\:X2 \4\:S10) capacitor c=1.15452e-18
    C2872 (\61\:vdd! \8\:I1\|net5) capacitor c=3.10538e-18
    C2873 (\116\:gnd! \1\:Y1) capacitor c=4.94706e-18
    C2874 (\123\:gnd! \9\:I7\|N_S) capacitor c=9.2598e-18
    C2875 (\97\:gnd! \71\:vdd!) capacitor c=1.12575e-16
    C2876 (\7\:net1 \4\:gnd!) capacitor c=1.32859e-17
    C2877 (\62\:gnd! \9\:I0\|N_S01) capacitor c=2.39628e-18
    C2878 (\7\:net7 \96\:vdd!) capacitor c=2.70186e-16
    C2879 (\34\:gnd! \4\:S01) capacitor c=9.22648e-18
    C2880 (\97\:gnd! \3\:I0\|net8) capacitor c=5.94386e-18
    C2881 (\36\:vdd! \5\:I1\|N_S00) capacitor c=3.25483e-17
    C2882 (\76\:vdd! \5\:I1\|N_S02) capacitor c=3.12455e-17
    C2883 (\7\:X2 \5\:net16) capacitor c=9.54406e-18
    C2884 (\14\:vdd! net3) capacitor c=2.21229e-18
    C2885 (\2\:Y0 \86\:vdd!) capacitor c=2.07497e-17
    C2886 (\4\:net3 \4\:gnd!) capacitor c=4.55286e-18
    C2887 (\6\:I0\|net6 \69\:gnd!) capacitor c=8.43891e-17
    C2888 (\123\:gnd! \5\:I7\|N_S) capacitor c=7.11623e-18
    C2889 (\41\:gnd! \4\:I0\|net5) capacitor c=3.6443e-18
    C2890 (\81\:vdd! net20) capacitor c=3.59519e-18
    C2891 (\83\:gnd! \61\:vdd!) capacitor c=1.53166e-16
    C2892 (\4\:gnd! \3\:S00) capacitor c=4.76525e-18
    C2893 (\96\:vdd! \4\:I8\|N_S) capacitor c=2.44444e-18
    C2894 (\83\:gnd! \3\:I1\|net6) capacitor c=4.55108e-18
    C2895 (\96\:vdd! Y3) capacitor c=4.73353e-18
    C2896 (\12\:net5 Y3) capacitor c=7.3699e-18
    C2897 (\69\:gnd! \8\:I0\|net6) capacitor c=5.36345e-18
    C2898 (\4\:Y7 \101\:vdd!) capacitor c=4.10953e-17
    C2899 (\86\:vdd! \1\:Y0) capacitor c=3.96496e-18
    C2900 (\18\:gnd! \6\:S31) capacitor c=1.54697e-18
    C2901 (S23 \3\:S14) capacitor c=1.19043e-17
    C2902 (\148\:gnd! \48\:gnd!) capacitor c=1.30711e-17
    C2903 (\130\:gnd! \9\:I9\|N_S) capacitor c=8.6091e-18
    C2904 (\8\:I0\|net9 \46\:vdd!) capacitor c=9.94942e-17
    C2905 (\51\:vdd! \3\:I0\|net5) capacitor c=1.72229e-18
    C2906 (\104\:gnd! \5\:I1\|net5) capacitor c=1.84993e-18
    C2907 (S23 \5\:net20) capacitor c=3.5949e-17
    C2908 (\46\:vdd! \1\:S02) capacitor c=1.02601e-18
    C2909 (\4\:net17 \48\:gnd!) capacitor c=7.69122e-18
    C2910 (\111\:gnd! \7\:net19) capacitor c=6.8868e-17
    C2911 (\61\:vdd! \3\:I1\|net2) capacitor c=2.0226e-17
    C2912 (\48\:gnd! \7\:I1\|N_S10) capacitor c=1.30336e-18
    C2913 (\71\:vdd! \7\:I7\|N_S) capacitor c=1.81698e-18
    C2914 (\8\:net22 Y3) capacitor c=1.88091e-17
    C2915 (\10\:net5 Y5) capacitor c=1.19629e-17
    C2916 (\2\:I0\|net6 \69\:gnd!) capacitor c=4.56169e-18
    C2917 (\83\:gnd! \8\:I1\|net10) capacitor c=4.77318e-18
    C2918 (\19\:vdd! \7\:I1\|N_S10) capacitor c=1.88634e-18
    C2919 (\41\:vdd! \8\:net16) capacitor c=4.29597e-18
    C2920 (\83\:gnd! \4\:S32) capacitor c=1.19162e-17
    C2921 (\25\:gnd! \3\:S30) capacitor c=4.52763e-18
    C2922 (\71\:vdd! \7\:I0\|N_S12) capacitor c=2.70339e-17
    C2923 (Y5 \5\:net20) capacitor c=2.81858e-17
    C2924 (\96\:vdd! \7\:I8\|N_S) capacitor c=2.43786e-17
    C2925 (\62\:gnd! \46\:vdd!) capacitor c=7.08239e-17
    C2926 (\19\:vdd! \6\:S31) capacitor c=1.49078e-17
    C2927 (\56\:vdd! \4\:I1\|N_S01) capacitor c=2.97371e-18
    C2928 (\81\:vdd! \2\:I1\|net8) capacitor c=1.25971e-17
    C2929 (\148\:gnd! \36\:vdd!) capacitor c=3.68794e-17
    C2930 (\90\:gnd! \4\:S03) capacitor c=1.00068e-17
    C2931 (\96\:vdd! \2\:Y4) capacitor c=9.30568e-17
    C2932 (\41\:vdd! \4\:I1\|N_S10) capacitor c=2.49561e-18
    C2933 (\96\:vdd! \6\:S34) capacitor c=2.0023e-18
    C2934 (\4\:gnd! \22\:vdd!) capacitor c=9.60092e-18
    C2935 (\55\:gnd! \4\:S31) capacitor c=1.1204e-17
    C2936 (\2\:net18 \4\:gnd!) capacitor c=5.35355e-17
    C2937 (\4\:vdd! \6\:I2\|N_S) capacitor c=1.6667e-17
    C2938 (\116\:gnd! 0) capacitor c=1.16002e-17
    C2939 (S24 \140\:gnd!) capacitor c=7.85544e-18
    C2940 (\46\:vdd! \6\:net3) capacitor c=3.61435e-18
    C2941 (\96\:vdd! vdd!) capacitor c=1.03582e-17
    C2942 (\55\:gnd! \3\:S31) capacitor c=1.70858e-18
    C2943 (\2\:Y5 S24) capacitor c=1.2893e-17
    C2944 (\7\:net19 \81\:vdd!) capacitor c=4.85581e-17
    C2945 (\6\:I0\|net8 \97\:gnd!) capacitor c=8.141e-17
    C2946 (\26\:vdd! \6\:net3) capacitor c=1.87821e-18
    C2947 (\3\:I1\|net5 \76\:gnd!) capacitor c=1.07722e-16
    C2948 (\123\:gnd! \2\:net6) capacitor c=7.3773e-18
    C2949 (\4\:net7 \86\:vdd!) capacitor c=5.54388e-16
    C2950 (\51\:vdd! \8\:I0\|N_S11) capacitor c=2.08658e-18
    C2951 (\7\:net1 \11\:gnd!) capacitor c=7.12111e-17
    C2952 (\36\:vdd! \2\:net17) capacitor c=4.98083e-18
    C2953 (\134\:gnd! 0) capacitor c=1.14494e-17
    C2954 (\26\:vdd! \7\:I0\|N_S00) capacitor c=1.60523e-17
    C2955 (\111\:gnd! \2\:net20) capacitor c=4.85174e-17
    C2956 (\55\:gnd! \8\:net16) capacitor c=4.33569e-18
    C2957 (\41\:vdd! \2\:net15) capacitor c=2.88134e-18
    C2958 (\51\:vdd! \2\:I0\|net6) capacitor c=1.1856e-17
    C2959 (\76\:gnd! \4\:S22) capacitor c=1.37071e-17
    C2960 (\104\:gnd! \76\:vdd!) capacitor c=6.30293e-17
    C2961 (\91\:vdd! \4\:S04) capacitor c=3.24725e-18
    C2962 (\123\:gnd! \2\:net5) capacitor c=1.1004e-17
    C2963 (\7\:net7 S24) capacitor c=3.34296e-18
    C2964 (\71\:vdd! \7\:I0\|net8) capacitor c=8.55809e-18
    C2965 (net18 \4\:vdd!) capacitor c=4.42799e-17
    C2966 (\130\:gnd! 0) capacitor c=1.11406e-17
    C2967 (\86\:vdd! \4\:I6\|N_S) capacitor c=2.36994e-18
    C2968 (\69\:gnd! \3\:I0\|net6) capacitor c=4.33821e-18
    C2969 (\51\:vdd! \6\:I0\|net10) capacitor c=2.10531e-17
    C2970 (\111\:gnd! \8\:I1\|net8) capacitor c=4.58339e-18
    C2971 (\31\:vdd! \7\:I0\|N_S10) capacitor c=1.93298e-17
    C2972 (\8\:I0\|net5 \62\:gnd!) capacitor c=4.68653e-17
    C2973 (\25\:gnd! \9\:I5\|N_S) capacitor c=3.81545e-18
    C2974 (\62\:gnd! \6\:I0\|net5) capacitor c=5.40178e-18
    C2975 (\31\:vdd! \4\:S01) capacitor c=1.61547e-18
    C2976 (\9\:S22 \69\:gnd!) capacitor c=3.63432e-18
    C2977 (\18\:gnd! \3\:S20) capacitor c=3.43447e-18
    C2978 (\97\:gnd! \2\:I0\|N_S12) capacitor c=7.54251e-19
    C2979 (S23 \140\:gnd!) capacitor c=1.505e-17
    C2980 (\17\:gnd! \9\:I4\|N_S) capacitor c=2.07346e-17
    C2981 (\4\:Y5 \96\:vdd!) capacitor c=5.16308e-17
    C2982 (\71\:vdd! \7\:I0\|net6) capacitor c=4.98594e-18
    C2983 (\76\:gnd! \6\:I1\|net9) capacitor c=9.20156e-18
    C2984 (\90\:gnd! \5\:I0\|net5) capacitor c=1.95817e-18
    C2985 (\76\:vdd! \3\:I1\|net1) capacitor c=7.82388e-17
    C2986 (\126\:gnd! \91\:vdd!) capacitor c=1.35309e-17
    C2987 (\139\:gnd! \3\:I8\|N_S) capacitor c=4.38591e-18
    C2988 (\7\:net21 \76\:vdd!) capacitor c=4.06249e-17
    C2989 (\4\:net3 \4\:vdd!) capacitor c=3.34045e-18
    C2990 (\41\:vdd! \6\:I1\|net10) capacitor c=2.74596e-17
    C2991 (S23 \3\:Y3) capacitor c=1.84198e-16
    C2992 (\36\:vdd! \7\:I1\|N_S00) capacitor c=2.35399e-17
    C2993 (\2\:net1 \14\:vdd!) capacitor c=5.44751e-17
    C2994 (\90\:gnd! \5\:I0\|net9) capacitor c=5.7085e-18
    C2995 (\10\:I1\|net3 \104\:gnd!) capacitor c=3.99218e-18
    C2996 (\71\:vdd! \5\:I0\|N_S12) capacitor c=3.62675e-17
    C2997 (\76\:gnd! \2\:net15) capacitor c=3.69877e-18
    C2998 (\7\:net16 \24\:gnd!) capacitor c=3.57343e-18
    C2999 (\86\:vdd! \5\:I6\|N_S) capacitor c=3.64097e-17
    C3000 (\7\:net16 \25\:gnd!) capacitor c=3.64259e-17
    C3001 (\14\:vdd! \3\:X4) capacitor c=8.4108e-18
    C3002 (\3\:I1\|net5 \41\:vdd!) capacitor c=3.80642e-18
    C3003 (\56\:vdd! \2\:net17) capacitor c=3.83895e-18
    C3004 (\123\:gnd! \7\:I7\|N_S) capacitor c=3.17339e-18
    C3005 (\9\:net18 \36\:vdd!) capacitor c=3.95055e-17
    C3006 (\69\:gnd! \4\:S12) capacitor c=1.00004e-17
    C3007 (\96\:vdd! \1\:Y4) capacitor c=2.22822e-18
    C3008 (\41\:vdd! \7\:I1\|N_S10) capacitor c=1.93145e-17
    C3009 (\31\:vdd! \5\:I0\|N_S10) capacitor c=3.68911e-17
    C3010 (\104\:gnd! \6\:S33) capacitor c=4.48569e-18
    C3011 (\111\:gnd! \3\:I1\|N_S12) capacitor c=1.47069e-18
    C3012 (\6\:I1\|net10 \76\:gnd!) capacitor c=9.14054e-18
    C3013 (\4\:net22 \96\:vdd!) capacitor c=3.19633e-16
    C3014 (\97\:gnd! \3\:I0\|N_S12) capacitor c=1.47459e-18
    C3015 (\111\:gnd! \8\:I1\|net3) capacitor c=4.37972e-18
    C3016 (\55\:gnd! \4\:net15) capacitor c=2.49601e-18
    C3017 (\97\:gnd! \8\:net6) capacitor c=5.10316e-18
    C3018 (\5\:I0\|N_S11 \62\:gnd!) capacitor c=8.67447e-18
    C3019 (\10\:net5 S34) capacitor c=4.81985e-17
    C3020 (\96\:vdd! \5\:I8\|N_S) capacitor c=3.06348e-17
    C3021 (\34\:gnd! \3\:I0\|N_S00) capacitor c=1.08288e-18
    C3022 (\10\:I0\|net10 \51\:vdd!) capacitor c=1.06639e-16
    C3023 (\25\:gnd! \6\:I5\|N_S) capacitor c=1.2068e-18
    C3024 (\61\:vdd! \3\:I1\|net6) capacitor c=1.66256e-18
    C3025 (\6\:S34 \139\:gnd!) capacitor c=7.72411e-17
    C3026 (\130\:gnd! \2\:net19) capacitor c=1.90108e-18
    C3027 (\41\:gnd! \5\:net1) capacitor c=3.79237e-18
    C3028 (\10\:gnd! \3\:S10) capacitor c=8.02426e-18
    C3029 (I0\|net10 \26\:vdd!) capacitor c=4.75398e-17
    C3030 (\111\:vdd! \96\:vdd!) capacitor c=1.09427e-17
    C3031 (\86\:vdd! \8\:net22) capacitor c=2.51031e-16
    C3032 (\111\:gnd! \2\:I1\|net8) capacitor c=5.29732e-18
    C3033 (\66\:vdd! S13) capacitor c=2.52985e-18
    C3034 (\5\:I1\|N_S01 \69\:gnd!) capacitor c=3.17966e-18
    C3035 (\14\:vdd! \6\:S21) capacitor c=1.71384e-18
    C3036 (\7\:net20 \81\:vdd!) capacitor c=2.57903e-17
    C3037 (\130\:gnd! \3\:S33) capacitor c=1.31533e-18
    C3038 (I0\|net6 \31\:vdd!) capacitor c=5.08669e-17
    C3039 (\6\:I1\|net8 \111\:gnd!) capacitor c=9.31803e-17
    C3040 (\91\:vdd! \5\:I7\|N_S) capacitor c=3.07626e-17
    C3041 (\5\:I1\|N_S02 \104\:gnd!) capacitor c=7.55131e-19
    C3042 (\81\:vdd! \5\:I1\|N_S12) capacitor c=3.63409e-17
    C3043 (\130\:gnd! \101\:vdd!) capacitor c=5.05463e-17
    C3044 (\4\:vdd! \3\:gnd!) capacitor c=1.34844e-17
    C3045 (\56\:vdd! \3\:I1\|net9) capacitor c=7.8338e-17
    C3046 (\5\:I0\|N_S12 \90\:gnd!) capacitor c=3.19839e-18
    C3047 (\26\:vdd! \4\:I0\|N_S00) capacitor c=2.49427e-18
    C3048 (\14\:vdd! \4\:S21) capacitor c=1.579e-18
    C3049 (\6\:S23 \97\:gnd!) capacitor c=1.009e-17
    C3050 (\18\:gnd! \9\:I4\|N_S) capacitor c=5.49904e-18
    C3051 (\71\:vdd! \2\:net5) capacitor c=1.14186e-17
    C3052 (S34 Y5) capacitor c=9.86643e-17
    C3053 (\36\:vdd! I1\|net10) capacitor c=4.84283e-17
    C3054 (\148\:gnd! \76\:gnd!) capacitor c=1.41468e-17
    C3055 (\4\:Y4 Y5) capacitor c=1.56357e-18
    C3056 (\2\:net1 \19\:vdd!) capacitor c=2.53822e-17
    C3057 (\69\:gnd! \8\:I0\|net10) capacitor c=4.45226e-18
    C3058 (\7\:X2 \6\:X2) capacitor c=3.36388e-18
    C3059 (\123\:gnd! \4\:S14) capacitor c=5.77768e-18
    C3060 (\96\:vdd! \4\:S24) capacitor c=1.92879e-18
    C3061 (\111\:gnd! \3\:S32) capacitor c=1.41804e-18
    C3062 (\4\:net2 \34\:gnd!) capacitor c=1.20833e-17
    C3063 (\66\:vdd! \6\:net8) capacitor c=1.5749e-18
    C3064 (\7\:I1\|N_S12 \104\:gnd!) capacitor c=2.69334e-18
    C3065 (\116\:gnd! \4\:S04) capacitor c=6.74873e-18
    C3066 (\81\:vdd! \7\:I9\|N_S) capacitor c=1.90294e-18
    C3067 (\62\:gnd! \4\:S02) capacitor c=1.31523e-17
    C3068 (\13\:net5 Y3) capacitor c=4.16248e-17
    C3069 (\5\:I1\|N_S11 \76\:gnd!) capacitor c=8.67447e-18
    C3070 (\104\:gnd! \4\:S23) capacitor c=1.00187e-17
    C3071 (\18\:gnd! \14\:vdd!) capacitor c=5.56631e-17
    C3072 (\41\:vdd! I1\|net6) capacitor c=5.09831e-17
    C3073 (\19\:vdd! S31) capacitor c=2.02372e-18
    C3074 (\14\:vdd! \4\:net17) capacitor c=1.26314e-17
    C3075 (\96\:vdd! Y5) capacitor c=1.71626e-18
    C3076 (\46\:vdd! I0\|net3) capacitor c=4.59691e-17
    C3077 (\41\:vdd! \4\:I1\|net5) capacitor c=1.27843e-18
    C3078 (\9\:vdd! \6\:I3\|N_S) capacitor c=2.18401e-17
    C3079 (\7\:net1 \41\:gnd!) capacitor c=1.06301e-16
    C3080 (I1\|net3 \56\:vdd!) capacitor c=4.58933e-17
    C3081 (S33 \111\:gnd!) capacitor c=3.73777e-18
    C3082 (\76\:gnd! \56\:vdd!) capacitor c=7.08666e-17
    C3083 (\159\:gnd! \46\:vdd!) capacitor c=2.02462e-17
    C3084 (\7\:net15 \25\:gnd!) capacitor c=1.28589e-17
    C3085 (\83\:gnd! \6\:net16) capacitor c=4.65361e-18
    C3086 (\55\:gnd! \3\:I1\|N_S10) capacitor c=1.64961e-18
    C3087 (net16 \9\:vdd!) capacitor c=4.211e-17
    C3088 (\9\:vdd! \3\:S00) capacitor c=1.32884e-18
    C3089 (\62\:gnd! \4\:net2) capacitor c=2.93391e-18
    C3090 (\36\:vdd! \3\:I1\|net9) capacitor c=1.79036e-17
    C3091 (\7\:I1\|N_S01 \69\:gnd!) capacitor c=1.23156e-18
    C3092 (\96\:vdd! \9\:I8\|N_S) capacitor c=2.62836e-18
    C3093 (\2\:I1\|net3 \104\:gnd!) capacitor c=1.15146e-17
    C3094 (\10\:I0\|net6 \69\:gnd!) capacitor c=8.22506e-17
    C3095 (\51\:vdd! \4\:I0\|N_S11) capacitor c=2.99273e-18
    C3096 (\130\:gnd! \3\:I9\|N_S) capacitor c=1.12615e-18
    C3097 (\83\:gnd! \2\:I1\|net6) capacitor c=3.45785e-18
    C3098 (\81\:vdd! \7\:I1\|N_S12) capacitor c=2.56934e-17
    C3099 (\130\:gnd! \10\:net5) capacitor c=7.27434e-18
    C3100 (Y6 S34) capacitor c=1.01896e-17
    C3101 (\9\:vdd! I3\|N_S) capacitor c=3.04723e-17
    C3102 (\96\:vdd! \2\:Y5) capacitor c=8.03634e-18
    C3103 (\123\:gnd! \6\:Y3) capacitor c=7.1696e-17
    C3104 (\69\:gnd! I0\|net8) capacitor c=6.86679e-17
    C3105 (S23 \126\:gnd!) capacitor c=9.5617e-18
    C3106 (\3\:Y3 Y3) capacitor c=3.58499e-18
    C3107 (\24\:gnd! \9\:I5\|N_S) capacitor c=2.07425e-17
    C3108 (\96\:vdd! \5\:net20) capacitor c=8.17733e-18
    C3109 (\51\:vdd! \6\:I0\|N_S11) capacitor c=2.33711e-17
    C3110 (\91\:vdd! \4\:net6) capacitor c=6.37045e-18
    C3111 (\48\:gnd! \4\:S21) capacitor c=9.27178e-18
    C3112 (\101\:vdd! \6\:S34) capacitor c=6.77759e-18
    C3113 (\111\:gnd! \9\:I1\|N_S12) capacitor c=5.03983e-18
    C3114 (\55\:gnd! \4\:I1\|net5) capacitor c=5.64361e-18
    C3115 (\76\:vdd! \7\:I1\|N_S02) capacitor c=2.02123e-17
    C3116 (\3\:net7 \66\:vdd!) capacitor c=4.88121e-17
    C3117 (\46\:vdd! \3\:I0\|net1) capacitor c=1.89945e-17
    C3118 (\76\:vdd! \2\:I1\|net3) capacitor c=1.18618e-17
    C3119 (\56\:vdd! \5\:I1\|net5) capacitor c=1.92389e-18
    C3120 (\83\:gnd! \3\:I1\|N_S11) capacitor c=1.49424e-18
    C3121 (\81\:vdd! \2\:net20) capacitor c=6.78003e-17
    C3122 (\62\:gnd! 0) capacitor c=2.23877e-17
    C3123 (\139\:gnd! \4\:S24) capacitor c=1.78673e-17
    C3124 (\21\:vdd! \34\:gnd!) capacitor c=2.25679e-17
    C3125 (\83\:gnd! I1\|net8) capacitor c=6.90043e-17
    C3126 (\104\:gnd! \5\:I1\|net9) capacitor c=5.7085e-18
    C3127 (\62\:gnd! \2\:I0\|net10) capacitor c=3.78243e-18
    C3128 (\51\:vdd! \3\:I0\|net6) capacitor c=1.67372e-18
    C3129 (\19\:vdd! \24\:gnd!) capacitor c=1.24185e-17
    C3130 (\46\:vdd! vdd!) capacitor c=1.26238e-17
    C3131 (\91\:vdd! \4\:I7\|N_S) capacitor c=1.98638e-18
    C3132 (\104\:gnd! \2\:I1\|N_S01) capacitor c=7.20153e-19
    C3133 (\5\:I9\|N_S \130\:gnd!) capacitor c=6.05254e-18
    C3134 (\4\:gnd! \4\:vdd!) capacitor c=2.67125e-17
    C3135 (\14\:vdd! \2\:X4) capacitor c=2.0075e-18
    C3136 (\86\:vdd! S14) capacitor c=3.36122e-18
    C3137 (\8\:I1\|net1 \76\:vdd!) capacitor c=3.425e-17
    C3138 (\96\:vdd! S24) capacitor c=3.334e-18
    C3139 (\62\:gnd! \8\:I0\|net9) capacitor c=1.33162e-18
    C3140 (\46\:vdd! \5\:I0\|net5) capacitor c=1.92389e-18
    C3141 (\123\:gnd! \7\:I0\|net3) capacitor c=3.879e-18
    C3142 (\62\:gnd! \6\:I0\|net9) capacitor c=9.3072e-18
    C3143 (\81\:vdd! \7\:I1\|net8) capacitor c=8.13702e-18
    C3144 (\48\:gnd! \6\:S31) capacitor c=2.8106e-18
    C3145 (S24 \3\:S14) capacitor c=3.8793e-18
    C3146 (\36\:vdd! \4\:net17) capacitor c=2.27965e-18
    C3147 (\7\:net1 \9\:vdd!) capacitor c=2.66449e-17
    C3148 (\97\:gnd! \7\:I0\|net10) capacitor c=4.45744e-18
    C3149 (S23 \4\:S14) capacitor c=2.17382e-17
    C3150 (\4\:net15 \25\:gnd!) capacitor c=6.93589e-17
    C3151 (\61\:vdd! \2\:I1\|net6) capacitor c=1.01103e-17
    C3152 (\4\:net17 \17\:gnd!) capacitor c=2.27351e-17
    C3153 (\46\:vdd! S12) capacitor c=3.90233e-18
    C3154 (\6\:net5 \97\:gnd!) capacitor c=4.95281e-18
    C3155 (\34\:gnd! \9\:I0\|N_S00) capacitor c=5.80069e-18
    C3156 (\130\:gnd! \7\:I9\|N_S) capacitor c=3.09671e-18
    C3157 (S23 \123\:gnd!) capacitor c=8.37132e-18
    C3158 (\91\:vdd! \116\:gnd!) capacitor c=3.82955e-17
    C3159 (\18\:gnd! \6\:I5\|N_S) capacitor c=1.85511e-18
    C3160 (\109\:vdd! \91\:vdd!) capacitor c=1.23982e-17
    C3161 (\111\:gnd! \3\:I1\|net8) capacitor c=6.16069e-18
    C3162 (\8\:I1\|net9 \56\:vdd!) capacitor c=9.95517e-17
    C3163 (\71\:vdd! \8\:I0\|net2) capacitor c=1.6719e-17
    C3164 (\86\:vdd! Y1) capacitor c=5.7996e-18
    C3165 (\61\:vdd! \6\:I1\|N_S11) capacitor c=2.23932e-17
    C3166 (\6\:I1\|net3 \104\:gnd!) capacitor c=3.06297e-17
    C3167 (\7\:I0\|N_S12 \90\:gnd!) capacitor c=2.69334e-18
    C3168 (\56\:vdd! \4\:S12) capacitor c=1.44661e-18
    C3169 (\101\:vdd! \4\:I9\|N_S) capacitor c=2.38485e-18
    C3170 (\26\:vdd! \5\:I0\|N_S00) capacitor c=3.14737e-17
    C3171 (\130\:gnd! \7\:I1\|net3) capacitor c=6.76503e-18
    C3172 (\119\:gnd! \86\:vdd!) capacitor c=1.34748e-17
    C3173 (\36\:vdd! \4\:I1\|N_S00) capacitor c=2.83165e-18
    C3174 (\139\:gnd! 0) capacitor c=1.79383e-17
    C3175 (\76\:gnd! \3\:I1\|N_S01) capacitor c=1.90778e-18
    C3176 (\6\:I1\|net6 \83\:gnd!) capacitor c=9.60471e-17
    C3177 (\11\:gnd! \9\:I3\|N_S) capacitor c=3.62117e-18
    C3178 (\76\:vdd! \5\:I1\|net5) capacitor c=3.92362e-18
    C3179 (\86\:vdd! \4\:net8) capacitor c=1.53308e-17
    C3180 (\46\:vdd! \2\:I0\|net10) capacitor c=1.23913e-17
    C3181 (\81\:vdd! \7\:I1\|net6) capacitor c=4.96903e-18
    C3182 (\31\:vdd! \6\:I0\|net10) capacitor c=2.72113e-17
    C3183 (\116\:gnd! \4\:net6) capacitor c=5.16799e-18
    C3184 (\9\:net18 \41\:gnd!) capacitor c=3.82326e-18
    C3185 (\7\:net16 \19\:vdd!) capacitor c=4.19085e-18
    C3186 (Y3 Y2) capacitor c=2.06818e-17
    C3187 (\31\:vdd! \3\:I0\|net5) capacitor c=4.13463e-18
    C3188 (\19\:vdd! \3\:S20) capacitor c=2.0439e-18
    C3189 (\76\:gnd! 0) capacitor c=1.99292e-17
    C3190 (\69\:gnd! net2) capacitor c=4.48433e-18
    C3191 (\101\:vdd! \4\:S24) capacitor c=3.1269e-18
    C3192 (\6\:I0\|net3 \66\:vdd!) capacitor c=5.03545e-18
    C3193 (\46\:vdd! \5\:I0\|N_S01) capacitor c=3.23314e-17
    C3194 (\19\:vdd! \4\:net17) capacitor c=6.6178e-18
    C3195 (\8\:net3 \4\:gnd!) capacitor c=6.26325e-18
    C3196 (\139\:gnd! \3\:S24) capacitor c=1.15818e-17
    C3197 (\90\:gnd! \3\:I0\|N_S02) capacitor c=1.12615e-18
    C3198 (\55\:gnd! \41\:vdd!) capacitor c=1.18157e-16
    C3199 (\96\:vdd! S23) capacitor c=4.25597e-18
    C3200 (\25\:gnd! \19\:vdd!) capacitor c=2.1969e-17
    C3201 (\56\:vdd! vdd!) capacitor c=1.1986e-17
    C3202 (\71\:vdd! \2\:I0\|net8) capacitor c=1.42877e-17
    C3203 (\61\:vdd! \3\:I1\|net5) capacitor c=1.72229e-18
    C3204 (\6\:S14 \116\:gnd!) capacitor c=1.6903e-17
    C3205 (\7\:net20 S34) capacitor c=3.8606e-17
    C3206 (\86\:vdd! \6\:net22) capacitor c=1.48603e-17
    C3207 (\51\:vdd! \5\:I0\|N_S11) capacitor c=3.69816e-17
    C3208 (\134\:gnd! \96\:vdd!) capacitor c=6.15787e-17
    C3209 (\26\:vdd! \4\:net4) capacitor c=1.00663e-17
    C3210 (\81\:vdd! \4\:I1\|N_S12) capacitor c=2.86823e-18
    C3211 (\8\:I0\|net5 \51\:vdd!) capacitor c=3.10538e-18
    C3212 (\123\:gnd! \91\:vdd!) capacitor c=4.90549e-17
    C3213 (\66\:vdd! \7\:I0\|N_S02) capacitor c=2.03236e-17
    C3214 (\51\:vdd! \4\:S02) capacitor c=1.18061e-18
    C3215 (S24 S23) capacitor c=2.60348e-16
    C3216 (\130\:gnd! \2\:net20) capacitor c=5.52549e-18
    C3217 (\31\:vdd! \4\:net2) capacitor c=6.08844e-18
    C3218 (\130\:gnd! \133\:gnd!) capacitor c=8.53971e-18
    C3219 (\8\:I1\|net5 \76\:gnd!) capacitor c=4.686e-17
    C3220 (\41\:vdd! \4\:S21) capacitor c=1.60931e-18
    C3221 (\4\:vdd! \2\:I2\|N_S) capacitor c=2.2543e-18
    C3222 (\9\:vdd! \7\:I0\|N_S10) capacitor c=1.82196e-18
    C3223 (\134\:gnd! \139\:gnd!) capacitor c=1.12891e-17
    C3224 (\69\:gnd! \3\:I0\|N_S11) capacitor c=1.62437e-18
    C3225 (\7\:net1 \10\:gnd!) capacitor c=5.95758e-18
    C3226 (\9\:S22 \56\:vdd!) capacitor c=3.78103e-18
    C3227 (\116\:gnd! \2\:Y1) capacitor c=7.01294e-17
    C3228 (\140\:gnd! Y3) capacitor c=5.83223e-17
    C3229 (\19\:vdd! I5\|N_S) capacitor c=3.3135e-17
    C3230 (\14\:vdd! \6\:I4\|N_S) capacitor c=2.4382e-17
    C3231 (\56\:vdd! \5\:I1\|N_S01) capacitor c=3.15811e-17
    C3232 (Y5 Y4) capacitor c=1.0905e-17
    C3233 (\41\:vdd! \10\:net16) capacitor c=2.78971e-18
    C3234 (\3\:gnd! \3\:S00) capacitor c=7.43372e-18
    C3235 (\3\:I0\|net2 \71\:vdd!) capacitor c=5.21201e-17
    C3236 (\90\:gnd! \66\:vdd!) capacitor c=6.61926e-17
    C3237 (\6\:S21 \10\:gnd!) capacitor c=1.21395e-17
    C3238 (\4\:vdd! I2\|N_S) capacitor c=3.02163e-17
    C3239 (\66\:vdd! \5\:I0\|N_S02) capacitor c=3.2387e-17
    C3240 (\11\:gnd! \6\:S21) capacitor c=6.04887e-18
    C3241 (\123\:gnd! \6\:net6) capacitor c=2.421e-18
    C3242 (\10\:I0\|net8 \97\:gnd!) capacitor c=8.1618e-17
    C3243 (\3\:I0\|net5 \62\:gnd!) capacitor c=1.07083e-16
    C3244 (\3\:I0\|net2 \51\:vdd!) capacitor c=2.02292e-17
    C3245 (\66\:vdd! \3\:I0\|net1) capacitor c=7.7752e-17
    C3246 (\2\:Y7 S34) capacitor c=1.24667e-17
    C3247 (\34\:gnd! I0\|net10) capacitor c=6.58447e-17
    C3248 (\96\:vdd! \8\:net22) capacitor c=2.70251e-16
    C3249 (\24\:gnd! \3\:S30) capacitor c=7.89838e-18
    C3250 (S34 \3\:S24) capacitor c=3.64397e-18
    C3251 (\4\:gnd! \9\:I2\|N_S) capacitor c=5.56567e-18
    C3252 (\86\:vdd! \7\:net7) capacitor c=9.07467e-17
    C3253 (\14\:vdd! \3\:S10) capacitor c=1.47158e-18
    C3254 (\81\:vdd! \8\:I1\|net2) capacitor c=1.67129e-17
    C3255 (\90\:gnd! \3\:S02) capacitor c=8.83341e-19
    C3256 (\41\:gnd! I0\|net6) capacitor c=6.80158e-17
    C3257 (\130\:gnd! \4\:Y7) capacitor c=7.21699e-17
    C3258 (\61\:vdd! \5\:I1\|N_S11) capacitor c=3.69779e-17
    C3259 (\81\:vdd! \6\:net19) capacitor c=1.20726e-17
    C3260 (\86\:vdd! \3\:Y1) capacitor c=6.06921e-18
    C3261 (\7\:net1 \69\:gnd!) capacitor c=4.01967e-18
    C3262 (\14\:vdd! \2\:I4\|N_S) capacitor c=2.20039e-18
    C3263 (S24 \5\:net20) capacitor c=2.72686e-17
    C3264 (\123\:gnd! \2\:Y2) capacitor c=1.68279e-17
    C3265 (net18 \4\:gnd!) capacitor c=9.29319e-18
    C3266 (\6\:net5 S23) capacitor c=5.22178e-18
    C3267 (\66\:vdd! \5\:I0\|net5) capacitor c=4.01677e-18
    C3268 (\48\:gnd! I1\|net10) capacitor c=6.58447e-17
    C3269 (\55\:gnd! net15) capacitor c=5.0593e-18
    C3270 (\48\:gnd! \3\:I1\|N_S00) capacitor c=1.08288e-18
    C3271 (\56\:vdd! \6\:S32) capacitor c=2.90433e-18
    C3272 (\71\:vdd! \4\:I0\|N_S12) capacitor c=2.7341e-18
    C3273 (\7\:net20 \130\:gnd!) capacitor c=7.4242e-17
    C3274 (\26\:vdd! \3\:I0\|net9) capacitor c=1.90903e-17
    C3275 (\90\:gnd! \9\:I0\|N_S02) capacitor c=3.97824e-18
    C3276 (\9\:vdd! \2\:I3\|N_S) capacitor c=1.91821e-18
    C3277 (\61\:vdd! \6\:I1\|net10) capacitor c=2.10531e-17
    C3278 (\11\:gnd! \9\:vdd!) capacitor c=1.92264e-17
    C3279 (\2\:net21 S24) capacitor c=9.74725e-17
    C3280 (\7\:net17 \14\:vdd!) capacitor c=5.24993e-17
    C3281 (\31\:vdd! \2\:net2) capacitor c=4.43871e-18
    C3282 (\10\:I0\|net3 \90\:gnd!) capacitor c=3.91328e-18
    C3283 (\46\:vdd! \4\:I0\|N_S01) capacitor c=2.97371e-18
    C3284 (\12\:net5 S24) capacitor c=5.1023e-18
    C3285 (\123\:gnd! \3\:Y2) capacitor c=4.62658e-18
    C3286 (\11\:gnd! \3\:I3\|N_S) capacitor c=9.17072e-19
    C3287 (\55\:gnd! I1\|net6) capacitor c=7.02464e-17
    C3288 (\48\:gnd! \36\:vdd!) capacitor c=4.62079e-17
    C3289 (\12\:net5 S23) capacitor c=6.45585e-18
    C3290 (\2\:net16 \7\:X2) capacitor c=2.80837e-18
    C3291 (\86\:vdd! Y0) capacitor c=7.70709e-18
    C3292 (\5\:I1\|N_S12 \104\:gnd!) capacitor c=3.19839e-18
    C3293 (\62\:gnd! \3\:I0\|N_S01) capacitor c=1.73018e-18
    C3294 (\41\:gnd! \4\:S11) capacitor c=8.61039e-18
    C3295 (\4\:Y0 \86\:vdd!) capacitor c=2.62662e-17
    C3296 (\8\:net22 S24) capacitor c=1.78932e-17
    C3297 (\10\:I1\|net10 \61\:vdd!) capacitor c=1.06449e-16
    C3298 (\86\:vdd! \1\:S04) capacitor c=9.34597e-19
    C3299 (\83\:gnd! \8\:I1\|N_S11) capacitor c=4.25684e-18
    C3300 (\4\:net15 \24\:gnd!) capacitor c=1.45366e-17
    C3301 (\76\:vdd! \4\:S13) capacitor c=1.44661e-18
    C3302 (\8\:net22 S23) capacitor c=3.05905e-17
    C3303 (\146\:gnd! \41\:vdd!) capacitor c=4.8759e-17
    C3304 (\96\:vdd! \10\:net7) capacitor c=6.86122e-18
    C3305 (\69\:gnd! \51\:vdd!) capacitor c=1.53795e-16
    C3306 (\6\:net21 \139\:gnd!) capacitor c=2.34822e-18
    C3307 (\2\:I1\|net10 \76\:gnd!) capacitor c=7.01714e-18
    C3308 (\104\:gnd! \7\:net21) capacitor c=6.59105e-17
    C3309 (\97\:gnd! \8\:I0\|net8) capacitor c=5.89411e-18
    C3310 (\130\:gnd! \6\:net19) capacitor c=9.11652e-18
    C3311 (\71\:vdd! \6\:net6) capacitor c=8.12063e-18
    C3312 (\91\:vdd! \7\:I7\|N_S) capacitor c=2.00786e-17
    C3313 (\19\:vdd! \2\:I5\|N_S) capacitor c=2.57304e-18
    C3314 (\83\:gnd! \3\:S31) capacitor c=1.36823e-18
    C3315 (\41\:gnd! \2\:net2) capacitor c=3.4565e-18
    C3316 (\41\:vdd! \5\:I1\|N_S10) capacitor c=3.68902e-17
    C3317 (\139\:gnd! \4\:Y5) capacitor c=8.2622e-17
    C3318 (\19\:vdd! \2\:net15) capacitor c=3.31096e-18
    C3319 (\83\:gnd! \8\:I1\|net6) capacitor c=5.56651e-18
    C3320 (\139\:gnd! \3\:Y5) capacitor c=1.64578e-16
    C3321 (\5\:I6\|N_S \116\:gnd!) capacitor c=9.13392e-19
    C3322 (S34 \5\:net20) capacitor c=2.82932e-17
    C3323 (\6\:I0\|net10 \62\:gnd!) capacitor c=9.4069e-18
    C3324 (\90\:gnd! \3\:I0\|net3) capacitor c=5.70096e-18
    C3325 (\96\:vdd! \6\:net21) capacitor c=3.636e-18
    C3326 (\111\:gnd! \81\:vdd!) capacitor c=9.27243e-17
    C3327 (\76\:vdd! vdd!) capacitor c=1.13156e-17
    C3328 (S23 Y3) capacitor c=1.48305e-16
    C3329 (\10\:I1\|net8 \111\:gnd!) capacitor c=9.89815e-17
    C3330 (\139\:gnd! \2\:I8\|N_S) capacitor c=2.18174e-18
    C3331 (\91\:vdd! \6\:S14) capacitor c=5.59174e-18
    C3332 (\6\:net5 \123\:gnd!) capacitor c=1.72935e-16
    C3333 (\11\:gnd! \6\:I3\|N_S) capacitor c=1.30974e-18
    C3334 (\97\:gnd! net5) capacitor c=6.86187e-17
    C3335 (\96\:vdd! \2\:net21) capacitor c=6.21288e-18
    C3336 (\2\:net18 \14\:vdd!) capacitor c=7.47078e-18
    C3337 (\66\:vdd! \4\:I0\|N_S02) capacitor c=2.27855e-18
    C3338 (\10\:S22 S24) capacitor c=1.59782e-16
    C3339 (\71\:vdd! \6\:S13) capacitor c=1.21466e-18
    C3340 (\104\:gnd! \3\:I1\|N_S02) capacitor c=1.14475e-18
    C3341 (\3\:gnd! \9\:I2\|N_S) capacitor c=2.07346e-17
    C3342 (\22\:vdd! \3\:gnd!) capacitor c=2.00838e-17
    C3343 (\71\:vdd! \4\:S03) capacitor c=1.35199e-18
    C3344 (\97\:gnd! \4\:S13) capacitor c=8.25172e-18
    C3345 (\111\:gnd! \4\:S33) capacitor c=1.19377e-17
    C3346 (S22 S24) capacitor c=6.71002e-17
    C3347 (\97\:gnd! \2\:I0\|net8) capacitor c=6.59456e-18
    C3348 (\46\:vdd! \3\:I0\|net9) capacitor c=7.7836e-17
    C3349 (\97\:gnd! \8\:I0\|net3) capacitor c=4.33732e-18
    C3350 (\3\:I1\|net2 \81\:vdd!) capacitor c=5.18069e-17
    C3351 (\10\:S22 S23) capacitor c=1.85285e-17
    C3352 (\61\:vdd! \4\:I1\|N_S11) capacitor c=2.98923e-18
    C3353 (S23 \6\:S24) capacitor c=1.41627e-16
    C3354 (\101\:vdd! \6\:net21) capacitor c=2.03245e-18
    C3355 (\14\:vdd! \17\:gnd!) capacitor c=1.40188e-17
    C3356 (\10\:I1\|net6 \83\:gnd!) capacitor c=9.63973e-17
    C3357 (\6\:S11 \3\:gnd!) capacitor c=5.09222e-18
    C3358 (\4\:gnd! \3\:I2\|N_S) capacitor c=1.09796e-18
    C3359 (\76\:gnd! \9\:I1\|N_S01) capacitor c=2.4305e-18
    C3360 (S24 \5\:I8\|N_S) capacitor c=9.17959e-19
    C3361 (\76\:vdd! \4\:I1\|N_S02) capacitor c=2.27855e-18
    C3362 (\56\:vdd! \2\:I1\|net10) capacitor c=1.35608e-17
    C3363 (\7\:net16 \55\:gnd!) capacitor c=5.13121e-17
    C3364 (\26\:vdd! \8\:net3) capacitor c=4.35674e-17
    C3365 (\10\:I0\|net3 \71\:vdd!) capacitor c=4.97434e-17
    C3366 (\41\:gnd! \31\:vdd!) capacitor c=1.18576e-16
    C3367 (\4\:gnd! \6\:S11) capacitor c=1.07197e-17
    C3368 (\4\:vdd! \2\:S00) capacitor c=7.64819e-19
    C3369 (\111\:vdd! \101\:vdd!) capacitor c=1.22701e-17
    C3370 (\159\:gnd! \34\:gnd!) capacitor c=1.30679e-17
    C3371 (\2\:net19 S34) capacitor c=6.62623e-17
    C3372 (S34 \139\:gnd!) capacitor c=9.50462e-17
    C3373 (\14\:vdd! I4\|N_S) capacitor c=3.27589e-17
    C3374 (\71\:vdd! vdd!) capacitor c=1.10558e-17
    C3375 (\148\:gnd! \56\:vdd!) capacitor c=2.02462e-17
    C3376 (\19\:vdd! \6\:I5\|N_S) capacitor c=2.43015e-17
    C3377 (\159\:gnd! \26\:vdd!) capacitor c=3.6886e-17
    C3378 (\4\:Y4 \96\:vdd!) capacitor c=8.92122e-17
    C3379 (\56\:vdd! \3\:I1\|net1) capacitor c=1.88708e-17
    C3380 (\6\:I0\|N_S11 \62\:gnd!) capacitor c=6.93731e-18
    C3381 (\116\:gnd! \86\:vdd!) capacitor c=1.48578e-17
    C3382 (\130\:gnd! \4\:S34) capacitor c=6.33115e-18
    C3383 (\19\:vdd! \1\:S30) capacitor c=1.76614e-17
    C3384 (\4\:Y4 S24) capacitor c=1.27778e-18
    C3385 (net5 \71\:vdd!) capacitor c=4.84399e-17
    C3386 (\51\:vdd! I0\|net8) capacitor c=4.83747e-17
    C3387 (\25\:gnd! \3\:I5\|N_S) capacitor c=1.09237e-18
    C3388 (\90\:gnd! \6\:S13) capacitor c=9.23554e-18
    C3389 (\86\:vdd! \7\:I6\|N_S) capacitor c=1.83447e-17
    C3390 (\97\:gnd! \2\:I0\|N_S11) capacitor c=7.43299e-19
    C3391 (net16 \11\:gnd!) capacitor c=6.65039e-17
    C3392 (\123\:gnd! \3\:I7\|N_S) capacitor c=1.69549e-18
    C3393 (\8\:net3 \4\:vdd!) capacitor c=1.84021e-17
    C3394 (\4\:net15 \19\:vdd!) capacitor c=2.40507e-18
    C3395 (\159\:gnd! \62\:gnd!) capacitor c=1.38749e-17
    C3396 (\46\:vdd! \7\:I0\|N_S01) capacitor c=1.99914e-17
    C3397 (\81\:vdd! vdd!) capacitor c=1.10363e-17
    C3398 (\81\:vdd! \6\:S33) capacitor c=3.47062e-18
    C3399 (\104\:gnd! \9\:I1\|N_S02) capacitor c=5.0922e-18
    C3400 (\96\:vdd! S22) capacitor c=4.61517e-18
    C3401 (\91\:vdd! \6\:Y3) capacitor c=4.09176e-17
    C3402 (\2\:net17 \41\:gnd!) capacitor c=6.18575e-18
    C3403 (\7\:net7 Y5) capacitor c=1.0118e-16
    C3404 (\96\:vdd! Y4) capacitor c=6.00773e-18
    C3405 (\61\:vdd! I1\|net8) capacitor c=4.83694e-17
    C3406 (\7\:net15 \19\:vdd!) capacitor c=4.63633e-17
    C3407 (\2\:net15 \48\:gnd!) capacitor c=1.29334e-17
    C3408 (\116\:gnd! \3\:I6\|N_S) capacitor c=1.20022e-18
    C3409 (\76\:gnd! \8\:I1\|net9) capacitor c=1.33162e-18
    C3410 (\62\:gnd! I0\|net3) capacitor c=7.56538e-17
    C3411 (\69\:gnd! \8\:I0\|N_S11) capacitor c=4.63323e-18
    C3412 (\76\:gnd! \6\:I1\|net5) capacitor c=5.40178e-18
    C3413 (\6\:S12 \62\:gnd!) capacitor c=2.58284e-17
    C3414 (\140\:gnd! 0) capacitor c=2.44934e-17
    C3415 (Y3 \5\:net20) capacitor c=4.23504e-17
    C3416 (\158\:gnd! \31\:vdd!) capacitor c=4.8947e-17
    C3417 (\101\:vdd! \6\:net19) capacitor c=4.50124e-18
    C3418 (\90\:gnd! \2\:I0\|net3) capacitor c=7.95323e-18
    C3419 (\61\:vdd! \7\:I1\|net6) capacitor c=2.03769e-18
    C3420 (\31\:vdd! \4\:I0\|N_S10) capacitor c=2.13676e-18
    C3421 (\48\:gnd! \9\:I1\|N_S00) capacitor c=5.97357e-18
    C3422 (\61\:vdd! S32) capacitor c=2.59892e-18
    C3423 (\76\:gnd! I1\|net3) capacitor c=7.57193e-17
    C3424 (\123\:gnd! \3\:net5) capacitor c=5.22009e-18
    C3425 (\11\:gnd! \3\:S10) capacitor c=6.08915e-18
    C3426 (\8\:I0\|net1 \66\:vdd!) capacitor c=7.9566e-17
    C3427 (\13\:net5 S24) capacitor c=7.71172e-18
    C3428 (\90\:gnd! \3\:net7) capacitor c=6.59105e-17
    C3429 (\6\:I1\|N_S11 \76\:gnd!) capacitor c=6.9353e-18
    C3430 (\97\:gnd! \9\:I0\|N_S12) capacitor c=5.75288e-18
    C3431 (\101\:vdd! \5\:I9\|N_S) capacitor c=2.98688e-17
    C3432 (\4\:net17 \18\:gnd!) capacitor c=8.64098e-17
    C3433 (\51\:vdd! \7\:I0\|net6) capacitor c=2.03841e-18
    C3434 (\6\:I0\|net3 \90\:gnd!) capacitor c=3.04314e-17
    C3435 (S32 \83\:gnd!) capacitor c=3.19278e-18
    C3436 (\123\:gnd! \4\:net6) capacitor c=6.1726e-18
    C3437 (\9\:net18 \14\:vdd!) capacitor c=1.10761e-17
    C3438 (\101\:vdd! \134\:gnd!) capacitor c=3.44374e-17
    C3439 (\34\:gnd! \6\:S11) capacitor c=3.16094e-18
    C3440 (\9\:vdd! \10\:gnd!) capacitor c=1.28055e-17
    C3441 (\111\:gnd! \7\:I1\|net10) capacitor c=4.91409e-18
    C3442 (\56\:vdd! \7\:I1\|N_S01) capacitor c=1.99376e-17
    C3443 (\66\:vdd! \2\:I0\|net3) capacitor c=1.07677e-17
    C3444 (\101\:vdd! \7\:I9\|N_S) capacitor c=1.93362e-17
    C3445 (\133\:gnd! \101\:vdd!) capacitor c=1.39579e-17
    C3446 (\3\:net16 \7\:X2) capacitor c=1.98814e-17
    C3447 (S23 \13\:net5) capacitor c=3.65654e-18
    C3448 (\17\:gnd! \3\:S20) capacitor c=6.48184e-18
    C3449 (\96\:vdd! \4\:S14) capacitor c=1.45493e-18
    C3450 (\31\:vdd! \4\:I0\|net5) capacitor c=1.29237e-18
    C3451 (\130\:gnd! \8\:net19) capacitor c=4.76119e-18
    C3452 (\34\:gnd! \26\:vdd!) capacitor c=3.66147e-17
    C3453 (\2\:net16 \19\:vdd!) capacitor c=2.49603e-18
    C3454 (\9\:S22 \97\:gnd!) capacitor c=6.01986e-18
    C3455 (\61\:vdd! \8\:I1\|N_S11) capacitor c=1.70682e-18
    C3456 (\41\:gnd! \3\:I0\|N_S10) capacitor c=1.52099e-18
    C3457 (\18\:gnd! \3\:I4\|N_S) capacitor c=1.12615e-18
    C3458 (\104\:gnd! \3\:I1\|net3) capacitor c=5.70096e-18
    C3459 (\108\:vdd! \116\:gnd!) capacitor c=3.18904e-17
    C3460 (\7\:I9\|N_S \6\:S34) capacitor c=6.38116e-19
    C3461 (\6\:S34 \5\:I9\|N_S) capacitor c=7.61081e-19
    C3462 (\2\:net4 \4\:S01) capacitor c=5.27777e-19
    C3463 (\4\:net4 \2\:S01) capacitor c=5.81547e-19
    C3464 (\111\:vdd! \3\:I8\|N_S) capacitor c=4.03344e-19
    C3465 (\2\:X7 \4\:S30) capacitor c=3.52514e-19
    C3466 (\2\:X7 \7\:S30) capacitor c=4.40958e-19
    C3467 (\2\:X6 \2\:S30) capacitor c=4.13974e-19
    C3468 (\5\:X6 S30) capacitor c=4.38415e-19
    C3469 (\3\:X6 \3\:S30) capacitor c=4.9415e-19
    C3470 (\104\:gnd! \2\:I1\|net8) capacitor c=1.29798e-18
    C3471 (\4\:net8 \3\:I6\|N_S) capacitor c=4.85411e-19
    C3472 (\91\:vdd! \6\:net6) capacitor c=6.96475e-19
    C3473 (\62\:gnd! \7\:S02) capacitor c=6.06259e-19
    C3474 (S31 \6\:S30) capacitor c=9.69367e-19
    C3475 (\148\:gnd! I1\|net3) capacitor c=7.82161e-19
    C3476 (\6\:I1\|net3 \105\:gnd!) capacitor c=1.09895e-18
    C3477 (\10\:I1\|net8 \6\:net19) capacitor c=1.37201e-18
    C3478 (\1\:Y1 \2\:S14) capacitor c=6.68627e-19
    C3479 (\46\:vdd! \5\:S02) capacitor c=3.32373e-19
    C3480 (\52\:vdd! \4\:S02) capacitor c=3.364e-19
    C3481 (\66\:vdd! \2\:S02) capacitor c=3.68164e-19
    C3482 (\2\:Y2 \3\:S14) capacitor c=3.82191e-19
    C3483 (\4\:Y2 \3\:S14) capacitor c=3.88117e-19
    C3484 (\1\:Y2 \2\:S14) capacitor c=4.94916e-19
    C3485 (Y2 \2\:S14) capacitor c=6.17091e-19
    C3486 (\4\:Y2 \2\:S14) capacitor c=7.04885e-19
    C3487 (\18\:gnd! \1\:S30) capacitor c=8.18973e-19
    C3488 (\83\:gnd! \2\:I1\|N_S10) capacitor c=5.30084e-19
    C3489 (\12\:net5 \5\:net20) capacitor c=2.76909e-18
    C3490 (\7\:S30 vdd!) capacitor c=1.05932e-18
    C3491 (\1\:X2 \5\:X2) capacitor c=4.17099e-19
    C3492 (\123\:gnd! \7\:S14) capacitor c=6.79066e-19
    C3493 (\123\:gnd! \6\:S14) capacitor c=1.25532e-18
    C3494 (\148\:gnd! \9\:I1\|N_S00) capacitor c=5.16473e-19
    C3495 (\148\:gnd! \2\:I1\|N_S00) capacitor c=7.31714e-19
    C3496 (\109\:vdd! \8\:net8) capacitor c=5.05964e-19
    C3497 (\108\:vdd! \4\:net8) capacitor c=6.17929e-19
    C3498 (\86\:vdd! \2\:net8) capacitor c=6.31292e-19
    C3499 (\108\:vdd! \6\:net8) capacitor c=8.00482e-19
    C3500 (\86\:vdd! net8) capacitor c=8.81633e-19
    C3501 (Y3 \3\:S14) capacitor c=6.63438e-19
    C3502 (\6\:Y3 \5\:S14) capacitor c=1.26708e-18
    C3503 (\1\:Y3 \7\:S14) capacitor c=1.3399e-18
    C3504 (\2\:net16 \4\:S30) capacitor c=5.50413e-19
    C3505 (\6\:S33 \5\:I1\|N_S12) capacitor c=5.18314e-19
    C3506 (\2\:net1 \5\:S30) capacitor c=5.61496e-19
    C3507 (\6\:S14 \86\:vdd!) capacitor c=7.64171e-19
    C3508 (\7\:S14 vdd!) capacitor c=9.64979e-19
    C3509 (\108\:vdd! \6\:S14) capacitor c=1.39756e-18
    C3510 (\111\:gnd! \2\:I1\|N_S11) capacitor c=6.35483e-19
    C3511 (\7\:net15 \3\:S30) capacitor c=8.07991e-19
    C3512 (\2\:X0 \2\:S00) capacitor c=4.13974e-19
    C3513 (\3\:X0 \3\:S00) capacitor c=4.8661e-19
    C3514 (\109\:vdd! \3\:I6\|N_S) capacitor c=4.04281e-19
    C3515 (\5\:I0\|net5 \7\:S02) capacitor c=4.40679e-19
    C3516 (\8\:I0\|net9 \5\:S02) capacitor c=3.38704e-19
    C3517 (\6\:I0\|net9 \4\:S02) capacitor c=5.27777e-19
    C3518 (\4\:net3 \2\:I4\|N_S) capacitor c=6.19018e-19
    C3519 (\2\:Y1 \1\:S04) capacitor c=3.68563e-19
    C3520 (\123\:gnd! \3\:S13) capacitor c=7.08151e-19
    C3521 (\97\:gnd! \6\:S13) capacitor c=8.28331e-19
    C3522 (\7\:I1\|N_S01 \77\:gnd!) capacitor c=6.19012e-19
    C3523 (\2\:net1 \8\:net17) capacitor c=1.07271e-18
    C3524 (\2\:net1 \7\:net17) capacitor c=1.52988e-18
    C3525 (\6\:I0\|net3 \7\:S02) capacitor c=3.4087e-19
    C3526 (\3\:I1\|net5 \62\:vdd!) capacitor c=1.00956e-18
    C3527 (\5\:X4 S20) capacitor c=3.01659e-19
    C3528 (\2\:X4 \2\:S20) capacitor c=3.79722e-19
    C3529 (\3\:X4 \3\:S20) capacitor c=3.9435e-19
    C3530 (\6\:net5 \7\:S14) capacitor c=4.53339e-19
    C3531 (\13\:net5 \3\:S14) capacitor c=5.87805e-19
    C3532 (\6\:net5 \3\:net5) capacitor c=1.23194e-18
    C3533 (\8\:net5 \10\:net5) capacitor c=1.3293e-18
    C3534 (\10\:net5 \11\:net5) capacitor c=1.70933e-18
    C3535 (\111\:gnd! \2\:I1\|N_S12) capacitor c=5.53927e-19
    C3536 (\51\:vdd! \5\:S13) capacitor c=2.691e-19
    C3537 (\109\:vdd! \2\:S13) capacitor c=2.99459e-19
    C3538 (\71\:vdd! \1\:S13) capacitor c=3.22919e-19
    C3539 (\77\:vdd! \4\:S13) capacitor c=4.1109e-19
    C3540 (\71\:vdd! \3\:S13) capacitor c=5.65019e-19
    C3541 (\71\:vdd! \5\:S13) capacitor c=8.92427e-19
    C3542 (\7\:S13 vdd!) capacitor c=9.98623e-19
    C3543 (\5\:X2 S10) capacitor c=4.62095e-19
    C3544 (\1\:X2 S10) capacitor c=5.23145e-19
    C3545 (\3\:X2 \3\:S10) capacitor c=5.47195e-19
    C3546 (\76\:vdd! \5\:I1\|net9) capacitor c=1.25041e-18
    C3547 (\2\:X5 \2\:S20) capacitor c=4.15255e-19
    C3548 (\2\:X5 \7\:S20) capacitor c=4.40958e-19
    C3549 (\91\:vdd! \3\:S03) capacitor c=2.69351e-19
    C3550 (\72\:vdd! \4\:S03) capacitor c=3.27729e-19
    C3551 (\66\:vdd! \5\:S03) capacitor c=5.1192e-19
    C3552 (\3\:Y0 \4\:S04) capacitor c=3.09437e-19
    C3553 (\2\:Y0 \2\:S04) capacitor c=3.29399e-19
    C3554 (\2\:Y0 \3\:S04) capacitor c=4.02108e-19
    C3555 (\1\:Y0 \2\:S04) capacitor c=4.94916e-19
    C3556 (\4\:Y0 \2\:S04) capacitor c=5.06181e-19
    C3557 (\4\:net6 \5\:S14) capacitor c=7.16317e-19
    C3558 (\4\:net6 \2\:S14) capacitor c=8.66063e-19
    C3559 (\2\:net6 \3\:S14) capacitor c=9.80097e-19
    C3560 (\7\:I7\|N_S \6\:S14) capacitor c=6.94108e-19
    C3561 (S14 I7\|N_S) capacitor c=7.27901e-19
    C3562 (\41\:gnd! \3\:I0\|net5) capacitor c=5.05664e-19
    C3563 (S20 \4\:S10) capacitor c=1.21534e-18
    C3564 (\3\:X0 \4\:I2\|N_S) capacitor c=4.14019e-19
    C3565 (\3\:net5 \7\:S13) capacitor c=8.50226e-19
    C3566 (\8\:net7 \10\:net7) capacitor c=2.02804e-18
    C3567 (\4\:net7 \2\:net7) capacitor c=3.43723e-18
    C3568 (\6\:I1\|net10 vdd!) capacitor c=1.12139e-18
    C3569 (\41\:vdd! I1\|net10) capacitor c=1.2127e-18
    C3570 (\81\:vdd! \7\:I1\|net10) capacitor c=1.27253e-18
    C3571 (S21 \6\:S20) capacitor c=1.02423e-18
    C3572 (\123\:gnd! \4\:S04) capacitor c=5.71753e-19
    C3573 (\159\:gnd! I0\|net6) capacitor c=9.59982e-19
    C3574 (\62\:gnd! \2\:I0\|net6) capacitor c=1.17385e-18
    C3575 (\97\:gnd! \7\:I0\|net6) capacitor c=1.45032e-18
    C3576 (\111\:vdd! \6\:I1\|net2) capacitor c=1.08911e-18
    C3577 (\4\:net3 \5\:I2\|N_S) capacitor c=2.70704e-19
    C3578 (\8\:net3 \5\:I2\|N_S) capacitor c=2.77361e-19
    C3579 (\8\:net3 \2\:I2\|N_S) capacitor c=3.78705e-19
    C3580 (\2\:net7 \7\:S03) capacitor c=2.3097e-19
    C3581 (\6\:I1\|net9 \4\:S22) capacitor c=5.27777e-19
    C3582 (\3\:I1\|net9 \6\:S22) capacitor c=9.37098e-19
    C3583 (\6\:I1\|net9 \3\:S22) capacitor c=9.524e-19
    C3584 (\111\:vdd! \6\:I1\|net1) capacitor c=6.05593e-19
    C3585 (\96\:vdd! \5\:I1\|net1) capacitor c=9.65241e-19
    C3586 (\2\:net16 \3\:X6) capacitor c=4.01691e-19
    C3587 (\6\:net6 \5\:S13) capacitor c=8.09024e-19
    C3588 (\109\:vdd! \4\:S04) capacitor c=4.08119e-19
    C3589 (\92\:vdd! \4\:S04) capacitor c=4.1109e-19
    C3590 (\86\:vdd! \5\:S04) capacitor c=5.03464e-19
    C3591 (\4\:Y4 \3\:S24) capacitor c=2.52155e-19
    C3592 (\3\:Y4 \4\:S24) capacitor c=3.09437e-19
    C3593 (\2\:Y4 \2\:S24) capacitor c=3.6983e-19
    C3594 (\2\:Y4 \3\:S24) capacitor c=3.92447e-19
    C3595 (\1\:Y4 \2\:S24) capacitor c=4.59564e-19
    C3596 (\2\:X7 \2\:I5\|N_S) capacitor c=3.14544e-19
    C3597 (\7\:net19 \2\:I1\|N_S12) capacitor c=6.09979e-19
    C3598 (\3\:Y6 \4\:S34) capacitor c=2.51992e-19
    C3599 (\2\:Y6 \1\:S34) capacitor c=2.70475e-19
    C3600 (\2\:Y6 \3\:S34) capacitor c=4.63824e-19
    C3601 (\1\:Y6 \2\:S34) capacitor c=4.76795e-19
    C3602 (S34 \4\:Y6) capacitor c=5.14003e-19
    C3603 (\4\:Y6 \3\:S34) capacitor c=5.40815e-19
    C3604 (\4\:net3 \7\:X2) capacitor c=5.0534e-19
    C3605 (\4\:net3 \2\:X2) capacitor c=7.74467e-19
    C3606 (\3\:net7 \2\:I0\|N_S02) capacitor c=5.9293e-19
    C3607 (\123\:gnd! \1\:Y1) capacitor c=6.6921e-19
    C3608 (\90\:gnd! \2\:I0\|net8) capacitor c=1.27347e-18
    C3609 (\14\:vdd! \3\:S20) capacitor c=5.88334e-19
    C3610 (\19\:vdd! \4\:S20) capacitor c=8.71314e-19
    C3611 (\7\:S20 vdd!) capacitor c=1.12504e-18
    C3612 (\14\:vdd! \1\:S20) capacitor c=1.29903e-18
    C3613 (\2\:X6 \3\:I5\|N_S) capacitor c=4.27843e-19
    C3614 (\41\:vdd! \3\:I1\|N_S10) capacitor c=5.18974e-19
    C3615 (\6\:I0\|net3 \91\:gnd!) capacitor c=1.09895e-18
    C3616 (\69\:gnd! \2\:I0\|N_S10) capacitor c=6.39088e-19
    C3617 (\56\:vdd! I1\|N_S00) capacitor c=3.63948e-19
    C3618 (\14\:vdd! \3\:I1\|N_S00) capacitor c=4.40336e-19
    C3619 (\3\:I1\|net1 \2\:S22) capacitor c=1.24978e-18
    C3620 (\6\:I1\|net6 \3\:I1\|net6) capacitor c=1.26362e-18
    C3621 (\10\:I1\|net6 \8\:I1\|net6) capacitor c=1.34926e-18
    C3622 (\109\:vdd! \2\:Y1) capacitor c=4.1007e-19
    C3623 (\109\:vdd! \1\:Y1) capacitor c=5.1743e-19
    C3624 (\91\:vdd! \1\:Y1) capacitor c=7.98314e-19
    C3625 (\6\:net22 \7\:S04) capacitor c=3.96899e-19
    C3626 (\7\:I0\|net8 \7\:S13) capacitor c=4.38027e-19
    C3627 (\6\:I0\|net8 \6\:S13) capacitor c=6.46142e-19
    C3628 (\10\:I0\|net8 \4\:S13) capacitor c=7.64188e-19
    C3629 (\159\:gnd! \9\:I0\|N_S00) capacitor c=5.16473e-19
    C3630 (\159\:gnd! \2\:I0\|N_S00) capacitor c=7.20302e-19
    C3631 (\8\:I0\|net3 \4\:S13) capacitor c=5.09213e-19
    C3632 (\10\:I0\|net3 \2\:S13) capacitor c=5.75039e-19
    C3633 (\8\:I0\|net3 \3\:S13) capacitor c=9.80097e-19
    C3634 (\81\:vdd! I1\|N_S11) capacitor c=4.19594e-19
    C3635 (\56\:vdd! \6\:I1\|N_S11) capacitor c=6.74515e-19
    C3636 (\2\:X2 \5\:I3\|N_S) capacitor c=3.33185e-19
    C3637 (\3\:X2 I3\|N_S) capacitor c=3.67487e-19
    C3638 (\2\:X2 \3\:I3\|N_S) capacitor c=4.61124e-19
    C3639 (\3\:X2 \4\:I3\|N_S) capacitor c=5.31897e-19
    C3640 (\55\:gnd! \7\:S31) capacitor c=3.64357e-19
    C3641 (\146\:gnd! \4\:S31) capacitor c=5.95215e-19
    C3642 (\4\:net3 \2\:S20) capacitor c=6.02197e-19
    C3643 (\2\:net3 \1\:S20) capacitor c=8.62343e-19
    C3644 (\4\:net3 \5\:S20) capacitor c=1.11002e-18
    C3645 (\2\:net20 \7\:net19) capacitor c=1.29013e-18
    C3646 (\2\:net20 \8\:net19) capacitor c=1.45041e-18
    C3647 (\2\:Y2 \6\:Y3) capacitor c=6.69698e-19
    C3648 (\76\:vdd! I1\|N_S01) capacitor c=3.68149e-19
    C3649 (S13 \5\:I0\|N_S02) capacitor c=5.96457e-19
    C3650 (\2\:net1 \6\:S20) capacitor c=6.88921e-19
    C3651 (\2\:net1 S20) capacitor c=7.86697e-19
    C3652 (\2\:net1 \4\:S20) capacitor c=1.31473e-18
    C3653 (\9\:S22 I1\|net3) capacitor c=1.04994e-18
    C3654 (I1\|net3 \5\:S22) capacitor c=1.41627e-18
    C3655 (\4\:gnd! \1\:S10) capacitor c=8.76252e-19
    C3656 (\7\:I0\|N_S01 \63\:gnd!) capacitor c=6.19059e-19
    C3657 (\90\:gnd! \2\:I0\|N_S01) capacitor c=7.11489e-19
    C3658 (\5\:I0\|net2 \7\:S03) capacitor c=4.40679e-19
    C3659 (\1\:S32 \2\:S32) capacitor c=1.01787e-18
    C3660 (\81\:vdd! \3\:I1\|N_S12) capacitor c=3.39057e-19
    C3661 (\101\:vdd! \5\:I1\|N_S12) capacitor c=3.43617e-19
    C3662 (\111\:vdd! \5\:I1\|N_S12) capacitor c=4.23539e-19
    C3663 (\8\:I0\|net1 \5\:S03) capacitor c=3.38704e-19
    C3664 (\8\:I0\|net1 \6\:S03) capacitor c=5.46258e-19
    C3665 (\6\:I0\|net1 \4\:S03) capacitor c=5.46341e-19
    C3666 (\7\:net21 \2\:I1\|N_S02) capacitor c=5.9293e-19
    C3667 (\3\:I0\|net9 I0\|net10) capacitor c=9.90953e-19
    C3668 (\10\:I0\|net6 \8\:I0\|net6) capacitor c=9.51381e-19
    C3669 (\111\:vdd! I1\|N_S02) capacitor c=3.72836e-19
    C3670 (\148\:gnd! \7\:S21) capacitor c=8.01138e-19
    C3671 (\76\:gnd! \3\:S21) capacitor c=8.08965e-19
    C3672 (\158\:gnd! \6\:S21) capacitor c=1.12873e-18
    C3673 (\148\:gnd! \3\:S21) capacitor c=1.13838e-18
    C3674 (\5\:I0\|N_S02 \90\:gnd!) capacitor c=7.55131e-19
    C3675 (\2\:net17 I4\|N_S) capacitor c=5.80225e-19
    C3676 (\7\:net17 \3\:I4\|N_S) capacitor c=6.88907e-19
    C3677 (\41\:vdd! \5\:S31) capacitor c=2.98492e-19
    C3678 (\41\:vdd! \7\:S31) capacitor c=4.83562e-19
    C3679 (\61\:vdd! \3\:S31) capacitor c=6.07806e-19
    C3680 (\7\:S31 vdd!) capacitor c=1.00094e-18
    C3681 (\10\:I1\|net10 \11\:I1\|net10) capacitor c=1.3439e-18
    C3682 (\8\:I1\|net10 \10\:I1\|net10) capacitor c=1.45736e-18
    C3683 (\3\:I0\|net6 \7\:S11) capacitor c=8.60322e-19
    C3684 (I0\|net6 \5\:S11) capacitor c=1.36098e-18
    C3685 (S11 \5\:S10) capacitor c=8.19721e-19
    C3686 (\3\:I0\|net5 \52\:vdd!) capacitor c=1.00956e-18
    C3687 (\7\:net17 \3\:S20) capacitor c=6.78602e-19
    C3688 (\8\:net17 \7\:S20) capacitor c=1.3739e-18
    C3689 (\7\:S10 vdd!) capacitor c=1.04875e-18
    C3690 (\83\:gnd! \7\:S32) capacitor c=6.31645e-19
    C3691 (\5\:net22 \3\:Y1) capacitor c=7.83004e-19
    C3692 (Y1 \6\:net22) capacitor c=9.98432e-19
    C3693 (\3\:I0\|net9 \47\:vdd!) capacitor c=5.13098e-19
    C3694 (\66\:vdd! \5\:I0\|net9) capacitor c=1.25041e-18
    C3695 (\6\:I1\|net5 \2\:I1\|net3) capacitor c=8.57575e-19
    C3696 (\6\:net8 \5\:S04) capacitor c=4.26281e-19
    C3697 (\2\:net8 \4\:S04) capacitor c=5.46819e-19
    C3698 (\4\:net8 \5\:S04) capacitor c=7.3698e-19
    C3699 (\1\:Y6 \2\:I9\|N_S) capacitor c=2.74618e-19
    C3700 (\5\:I1\|N_S01 \2\:S22) capacitor c=4.36616e-19
    C3701 (\2\:X4 \3\:I4\|N_S) capacitor c=4.85411e-19
    C3702 (\4\:net22 I8\|N_S) capacitor c=8.20638e-19
    C3703 (\42\:vdd! \4\:S21) capacitor c=3.37349e-19
    C3704 (\56\:vdd! \2\:S21) capacitor c=3.63963e-19
    C3705 (\36\:vdd! \5\:S21) capacitor c=6.09788e-19
    C3706 (\36\:vdd! \6\:S21) capacitor c=7.51659e-19
    C3707 (\7\:S21 vdd!) capacitor c=1.00094e-18
    C3708 (\1\:S33 \2\:S33) capacitor c=1.02264e-18
    C3709 (\6\:I0\|net10 vdd!) capacitor c=9.81688e-19
    C3710 (\71\:vdd! \7\:I0\|net10) capacitor c=1.26521e-18
    C3711 (\31\:vdd! I0\|net10) capacitor c=1.2733e-18
    C3712 (\22\:vdd! I0\|net10) capacitor c=2.15368e-18
    C3713 (\3\:I1\|net5 \5\:I1\|N_S10) capacitor c=7.12602e-19
    C3714 (\111\:gnd! \3\:S33) capacitor c=6.12634e-19
    C3715 (\7\:S24 vdd!) capacitor c=9.64979e-19
    C3716 (\96\:vdd! \5\:S24) capacitor c=1.29662e-18
    C3717 (\2\:net16 \6\:S31) capacitor c=4.78391e-19
    C3718 (\7\:net16 S31) capacitor c=6.61778e-19
    C3719 (\9\:I1\|N_S02 \3\:S22) capacitor c=3.7287e-19
    C3720 (\10\:I0\|net10 \11\:I0\|net10) capacitor c=1.3439e-18
    C3721 (\8\:I0\|net10 \10\:I0\|net10) capacitor c=1.45736e-18
    C3722 (\109\:vdd! \6\:I0\|net2) capacitor c=1.08911e-18
    C3723 (\11\:gnd! \8\:gnd!) capacitor c=7.80933e-19
    C3724 (\134\:gnd! \137\:gnd!) capacitor c=1.06665e-18
    C3725 (\148\:gnd! \77\:gnd!) capacitor c=1.22151e-18
    C3726 (\159\:gnd! \63\:gnd!) capacitor c=1.22151e-18
    C3727 (\55\:gnd! \56\:gnd!) capacitor c=2.64061e-18
    C3728 (\158\:gnd! \42\:gnd!) capacitor c=2.72791e-18
    C3729 (\146\:gnd! \56\:gnd!) capacitor c=2.85319e-18
    C3730 (\158\:gnd! \41\:gnd!) capacitor c=3.01783e-18
    C3731 (\4\:gnd! 0) capacitor c=3.03153e-18
    C3732 (\55\:gnd! \146\:gnd!) capacitor c=3.14591e-18
    C3733 (\62\:gnd! \63\:gnd!) capacitor c=3.17413e-18
    C3734 (\76\:gnd! \77\:gnd!) capacitor c=3.17413e-18
    C3735 (\69\:gnd! \70\:gnd!) capacitor c=3.25507e-18
    C3736 (\11\:gnd! 0) capacitor c=3.33165e-18
    C3737 (\41\:gnd! 0) capacitor c=3.33529e-18
    C3738 (\18\:gnd! 0) capacitor c=3.36769e-18
    C3739 (\97\:gnd! \98\:gnd!) capacitor c=3.50223e-18
    C3740 (\41\:gnd! \42\:gnd!) capacitor c=3.52477e-18
    C3741 (\83\:gnd! \84\:gnd!) capacitor c=3.64297e-18
    C3742 (\134\:gnd! \136\:gnd!) capacitor c=3.72172e-18
    C3743 (\111\:gnd! \112\:gnd!) capacitor c=3.79513e-18
    C3744 (\119\:gnd! \118\:gnd!) capacitor c=3.91009e-18
    C3745 (\126\:gnd! \125\:gnd!) capacitor c=3.97786e-18
    C3746 (\133\:gnd! \132\:gnd!) capacitor c=4.11464e-18
    C3747 (\25\:gnd! 0) capacitor c=4.14221e-18
    C3748 (\97\:gnd! 0) capacitor c=4.58556e-18
    C3749 (\69\:gnd! 0) capacitor c=4.61045e-18
    C3750 (\90\:gnd! 0) capacitor c=4.69035e-18
    C3751 (\90\:gnd! \91\:gnd!) capacitor c=4.83354e-18
    C3752 (\104\:gnd! \105\:gnd!) capacitor c=4.83354e-18
    C3753 (\146\:gnd! 0) capacitor c=4.86063e-18
    C3754 (\146\:gnd! \48\:gnd!) capacitor c=5.11884e-18
    C3755 (\158\:gnd! \34\:gnd!) capacitor c=5.12645e-18
    C3756 (\24\:gnd! \22\:gnd!) capacitor c=5.23275e-18
    C3757 (\104\:gnd! 0) capacitor c=5.45225e-18
    C3758 (\83\:gnd! 0) capacitor c=5.59289e-18
    C3759 (\34\:gnd! \35\:gnd!) capacitor c=5.60707e-18
    C3760 (\3\:gnd! \1\:gnd!) capacitor c=5.63055e-18
    C3761 (\48\:gnd! \49\:gnd!) capacitor c=5.67662e-18
    C3762 (\55\:gnd! 0) capacitor c=5.76826e-18
    C3763 (\25\:gnd! \24\:gnd!) capacitor c=6.03819e-18
    C3764 (\123\:gnd! 0) capacitor c=6.25628e-18
    C3765 (\10\:gnd! \8\:gnd!) capacitor c=6.38322e-18
    C3766 (\111\:gnd! 0) capacitor c=6.38908e-18
    C3767 (\158\:gnd! 0) capacitor c=6.42984e-18
    C3768 (\11\:gnd! \10\:gnd!) capacitor c=6.47935e-18
    C3769 (\48\:gnd! 0) capacitor c=6.57943e-18
    C3770 (\159\:gnd! 0) capacitor c=6.59644e-18
    C3771 (\18\:gnd! \17\:gnd!) capacitor c=6.62983e-18
    C3772 (\148\:gnd! 0) capacitor c=6.67686e-18
    C3773 (\17\:gnd! \15\:gnd!) capacitor c=6.71647e-18
    C3774 (\4\:gnd! \3\:gnd!) capacitor c=6.84142e-18
    C3775 (\34\:gnd! 0) capacitor c=7.08036e-18
    C3776 (\123\:gnd! \126\:gnd!) capacitor c=7.95927e-18
    C3777 (\61\:vdd! \4\:S32) capacitor c=4.33158e-19
    C3778 (\81\:vdd! \2\:S32) capacitor c=4.71953e-19
    C3779 (\61\:vdd! \1\:S32) capacitor c=4.82012e-19
    C3780 (\61\:vdd! \6\:S32) capacitor c=7.62241e-19
    C3781 (\61\:vdd! \3\:S32) capacitor c=7.81771e-19
    C3782 (\7\:S32 vdd!) capacitor c=1.00094e-18
    C3783 (\61\:vdd! \5\:S32) capacitor c=1.03073e-18
    C3784 (net16 \2\:S10) capacitor c=1.23632e-18
    C3785 (\5\:net16 \7\:S10) capacitor c=1.26683e-18
    C3786 (\109\:vdd! \6\:I0\|net1) capacitor c=7.95128e-19
    C3787 (\108\:vdd! \5\:I0\|net1) capacitor c=9.65241e-19
    C3788 (\4\:net3 \5\:S10) capacitor c=7.17536e-19
    C3789 (\4\:net3 \6\:S10) capacitor c=7.83697e-19
    C3790 (\4\:net3 \4\:S10) capacitor c=1.02722e-18
    C3791 (\13\:net5 \1\:Y2) capacitor c=3.52578e-19
    C3792 (\4\:net4 I0\|N_S00) capacitor c=6.32625e-19
    C3793 (\6\:I0\|net5 \2\:I0\|net3) capacitor c=8.57575e-19
    C3794 (\2\:net1 S10) capacitor c=5.42055e-19
    C3795 (\2\:net1 \6\:S10) capacitor c=5.81197e-19
    C3796 (\2\:net1 \1\:S10) capacitor c=1.14162e-18
    C3797 (\5\:I8\|N_S \8\:net7) capacitor c=4.14298e-19
    C3798 (\8\:net7 \2\:I8\|N_S) capacitor c=4.31079e-19
    C3799 (\10\:net7 \3\:I8\|N_S) capacitor c=4.85411e-19
    C3800 (\76\:vdd! \5\:S23) capacitor c=4.70191e-19
    C3801 (\111\:vdd! \6\:S23) capacitor c=7.99702e-19
    C3802 (\7\:S23 vdd!) capacitor c=1.00094e-18
    C3803 (\81\:vdd! \4\:S23) capacitor c=1.35204e-18
    C3804 (\111\:vdd! \3\:S23) capacitor c=1.75697e-18
    C3805 (\2\:X5 I4\|N_S) capacitor c=4.33045e-19
    C3806 (\10\:I0\|net3 \66\:vdd!) capacitor c=1.82407e-18
    C3807 (I0\|net3 vdd!) capacitor c=2.53772e-18
    C3808 (\13\:net5 \2\:I7\|N_S) capacitor c=3.46379e-19
    C3809 (\6\:net5 \3\:I7\|N_S) capacitor c=6.78631e-19
    C3810 (S33 vdd!) capacitor c=3.41026e-19
    C3811 (\81\:vdd! \3\:S33) capacitor c=3.60629e-19
    C3812 (\111\:vdd! \2\:S33) capacitor c=4.98238e-19
    C3813 (\81\:vdd! \5\:S33) capacitor c=9.15232e-19
    C3814 (\76\:vdd! \6\:S33) capacitor c=9.46093e-19
    C3815 (\7\:S33 vdd!) capacitor c=9.98623e-19
    C3816 (\11\:gnd! \6\:S11) capacitor c=4.08752e-19
    C3817 (\158\:gnd! \4\:S11) capacitor c=4.21897e-19
    C3818 (\69\:gnd! \3\:S11) capacitor c=5.70751e-19
    C3819 (\158\:gnd! \6\:S11) capacitor c=1.41003e-18
    C3820 (\4\:Y5 \4\:S24) capacitor c=1.23712e-18
    C3821 (\4\:Y5 \5\:S24) capacitor c=1.25013e-18
    C3822 (\1\:Y5 \7\:S24) capacitor c=1.37099e-18
    C3823 (Y5 \3\:S24) capacitor c=1.46016e-18
    C3824 (\6\:net22 \5\:I6\|N_S) capacitor c=6.34727e-19
    C3825 (\6\:net22 \2\:I6\|N_S) capacitor c=8.1683e-19
    C3826 (\31\:vdd! \3\:I0\|N_S10) capacitor c=5.24987e-19
    C3827 (\36\:vdd! \9\:I0\|N_S10) capacitor c=6.46602e-19
    C3828 (\3\:S22 \5\:S23) capacitor c=1.23797e-18
    C3829 (\2\:net15 \5\:S31) capacitor c=1.08398e-18
    C3830 (\19\:vdd! \17\:gnd!) capacitor c=6.78912e-19
    C3831 (\4\:gnd! \5\:vdd!) capacitor c=7.35602e-19
    C3832 (\18\:gnd! \15\:vdd!) capacitor c=7.35602e-19
    C3833 (\34\:gnd! \27\:vdd!) capacitor c=7.71661e-19
    C3834 (\48\:gnd! \37\:vdd!) capacitor c=7.71661e-19
    C3835 (\56\:gnd! \41\:vdd!) capacitor c=8.11767e-19
    C3836 (\42\:gnd! \31\:vdd!) capacitor c=8.18084e-19
    C3837 (\158\:gnd! \10\:vdd!) capacitor c=8.66998e-19
    C3838 (\123\:gnd! \92\:vdd!) capacitor c=8.87015e-19
    C3839 (\90\:gnd! \109\:vdd!) capacitor c=9.01483e-19
    C3840 (\111\:vdd! \104\:gnd!) capacitor c=9.01483e-19
    C3841 (\36\:vdd! \41\:gnd!) capacitor c=9.07169e-19
    C3842 (\109\:vdd! \119\:gnd!) capacitor c=9.3558e-19
    C3843 (\111\:vdd! \137\:gnd!) capacitor c=9.3558e-19
    C3844 (\146\:gnd! \20\:vdd!) capacitor c=9.67959e-19
    C3845 (\90\:gnd! \67\:vdd!) capacitor c=9.9222e-19
    C3846 (\104\:gnd! \77\:vdd!) capacitor c=9.9222e-19
    C3847 (\9\:vdd! \159\:gnd!) capacitor c=1.14961e-18
    C3848 (\130\:gnd! \102\:vdd!) capacitor c=1.20948e-18
    C3849 (\35\:gnd! \26\:vdd!) capacitor c=1.29965e-18
    C3850 (\11\:gnd! \10\:vdd!) capacitor c=1.34133e-18
    C3851 (\25\:gnd! \20\:vdd!) capacitor c=1.34936e-18
    C3852 (\49\:gnd! \36\:vdd!) capacitor c=1.47334e-18
    C3853 (\91\:gnd! \66\:vdd!) capacitor c=1.51376e-18
    C3854 (\105\:gnd! \76\:vdd!) capacitor c=1.51376e-18
    C3855 (\70\:gnd! \51\:vdd!) capacitor c=1.62096e-18
    C3856 (\98\:gnd! \71\:vdd!) capacitor c=1.65481e-18
    C3857 (\34\:gnd! \22\:vdd!) capacitor c=1.70667e-18
    C3858 (\84\:gnd! \61\:vdd!) capacitor c=1.72789e-18
    C3859 (\112\:gnd! \81\:vdd!) capacitor c=1.81528e-18
    C3860 (\101\:vdd! \139\:gnd!) capacitor c=1.96071e-18
    C3861 (\111\:vdd! \139\:gnd!) capacitor c=2.02572e-18
    C3862 (\63\:gnd! \46\:vdd!) capacitor c=2.10229e-18
    C3863 (\77\:gnd! \56\:vdd!) capacitor c=2.10229e-18
    C3864 (\158\:gnd! vdd!) capacitor c=2.61592e-18
    C3865 (\146\:gnd! vdd!) capacitor c=2.80116e-18
    C3866 (vdd! \104\:gnd!) capacitor c=3.2023e-18
    C3867 (\130\:gnd! vdd!) capacitor c=3.68858e-18
    C3868 (\81\:vdd! \130\:gnd!) capacitor c=3.76939e-18
    C3869 (\19\:vdd! \148\:gnd!) capacitor c=3.90308e-18
    C3870 (\123\:gnd! vdd!) capacitor c=3.93771e-18
    C3871 (\4\:gnd! \21\:vdd!) capacitor c=4.79663e-18
    C3872 (\84\:gnd! \62\:vdd!) capacitor c=4.80137e-18
    C3873 (\70\:gnd! \52\:vdd!) capacitor c=4.80163e-18
    C3874 (\91\:gnd! \67\:vdd!) capacitor c=4.84956e-18
    C3875 (\105\:gnd! \77\:vdd!) capacitor c=4.84956e-18
    C3876 (\48\:gnd! \14\:vdd!) capacitor c=4.85165e-18
    C3877 (\17\:gnd! \15\:vdd!) capacitor c=4.99999e-18
    C3878 (\49\:gnd! \37\:vdd!) capacitor c=5.05298e-18
    C3879 (\3\:gnd! \5\:vdd!) capacitor c=5.08791e-18
    C3880 (\35\:gnd! \27\:vdd!) capacitor c=5.14618e-18
    C3881 (\98\:gnd! \72\:vdd!) capacitor c=5.16077e-18
    C3882 (\112\:gnd! \82\:vdd!) capacitor c=5.23666e-18
    C3883 (\63\:gnd! \47\:vdd!) capacitor c=5.62071e-18
    C3884 (\77\:gnd! \57\:vdd!) capacitor c=5.62071e-18
    C3885 (\56\:gnd! \42\:vdd!) capacitor c=5.69171e-18
    C3886 (\42\:gnd! \32\:vdd!) capacitor c=5.72705e-18
    C3887 (\133\:gnd! \102\:vdd!) capacitor c=5.77119e-18
    C3888 (\119\:gnd! \87\:vdd!) capacitor c=5.88709e-18
    C3889 (\126\:gnd! \92\:vdd!) capacitor c=5.88709e-18
    C3890 (\137\:gnd! \97\:vdd!) capacitor c=5.88709e-18
    C3891 (\10\:gnd! \10\:vdd!) capacitor c=5.88709e-18
    C3892 (\24\:gnd! \20\:vdd!) capacitor c=5.88709e-18
    C3893 (\96\:vdd! \139\:gnd!) capacitor c=6.79422e-18
    C3894 (\96\:vdd! \137\:gnd!) capacitor c=6.85364e-18
    C3895 (\158\:gnd! \32\:vdd!) capacitor c=7.03527e-18
    C3896 (\146\:gnd! \42\:vdd!) capacitor c=7.03586e-18
    C3897 (\9\:vdd! \158\:gnd!) capacitor c=7.17016e-18
    C3898 (\19\:vdd! \146\:gnd!) capacitor c=7.17016e-18
    C3899 (\22\:vdd! \159\:gnd!) capacitor c=7.90337e-18
    C3900 (\18\:gnd! \19\:vdd!) capacitor c=8.35603e-18
    C3901 (\22\:vdd! \3\:I0\|N_S00) capacitor c=6.74179e-19
    C3902 (\2\:Y4 I8\|N_S) capacitor c=6.70572e-19
    C3903 (\7\:net18 \3\:S21) capacitor c=9.524e-19
    C3904 (\9\:net18 \5\:S21) capacitor c=9.75146e-19
    C3905 (\139\:gnd! \1\:S34) capacitor c=5.96747e-19
    C3906 (\139\:gnd! \2\:S34) capacitor c=5.97688e-19
    C3907 (\130\:gnd! \6\:S34) capacitor c=9.3215e-19
    C3908 (\21\:vdd! \2\:S00) capacitor c=7.04263e-19
    C3909 (\3\:Y7 \4\:Y7) capacitor c=1.02904e-18
    C3910 (\71\:vdd! I0\|N_S11) capacitor c=4.22619e-19
    C3911 (\46\:vdd! \6\:I0\|N_S11) capacitor c=6.74515e-19
    C3912 (\76\:gnd! \7\:S22) capacitor c=6.10312e-19
    C3913 (\104\:gnd! \3\:S22) capacitor c=8.94733e-19
    C3914 (\10\:S22 \123\:gnd!) capacitor c=1.07623e-18
    C3915 (\10\:S22 \126\:gnd!) capacitor c=1.13067e-18
    C3916 (\10\:S22 \140\:gnd!) capacitor c=1.74266e-18
    C3917 (I0\|net10 \7\:S01) capacitor c=5.95838e-19
    C3918 (\6\:I0\|net10 \7\:S01) capacitor c=7.15322e-19
    C3919 (\66\:vdd! I0\|N_S01) capacitor c=3.68149e-19
    C3920 (\62\:gnd! \3\:S01) capacitor c=5.27173e-19
    C3921 (\2\:I0\|net8 \1\:S22) capacitor c=8.90035e-19
    C3922 (\2\:I0\|net8 \2\:S22) capacitor c=1.42232e-18
    C3923 (\5\:net20 \3\:S24) capacitor c=1.09661e-18
    C3924 (I1\|net10 \2\:I1\|N_S00) capacitor c=7.76771e-19
    C3925 (\2\:net7 \3\:I6\|N_S) capacitor c=6.14122e-19
    C3926 (\4\:net22 \5\:S24) capacitor c=7.82841e-19
    C3927 (\4\:net22 S24) capacitor c=1.04672e-18
    C3928 (\4\:net22 \1\:S24) capacitor c=1.17415e-18
    C3929 (\4\:net22 \6\:S24) capacitor c=1.38051e-18
    C3930 (\10\:I1\|net3 \8\:I1\|net1) capacitor c=1.05657e-18
    C3931 (\6\:I1\|net8 \3\:I1\|net8) capacitor c=1.26342e-18
    C3932 (\71\:vdd! \2\:I0\|N_S12) capacitor c=4.08473e-19
    C3933 (\66\:vdd! \5\:I0\|N_S12) capacitor c=4.26003e-19
    C3934 (\6\:net2 \5\:S10) capacitor c=1.2255e-18
    C3935 (\4\:Y7 \5\:S34) capacitor c=1.26708e-18
    C3936 (\1\:Y7 \7\:S34) capacitor c=1.35205e-18
    C3937 (\37\:vdd! \4\:S11) capacitor c=4.1109e-19
    C3938 (\31\:vdd! \7\:S11) capacitor c=4.78839e-19
    C3939 (\51\:vdd! \3\:S11) capacitor c=5.88861e-19
    C3940 (\7\:S11 vdd!) capacitor c=1.00094e-18
    C3941 (\36\:vdd! \4\:S11) capacitor c=1.44661e-18
    C3942 (\6\:net5 \6\:S24) capacitor c=1.01066e-18
    C3943 (\6\:I3\|N_S \1\:S10) capacitor c=6.36143e-19
    C3944 (S10 \5\:I3\|N_S) capacitor c=7.77314e-19
    C3945 (\97\:gnd! \3\:S12) capacitor c=6.66909e-19
    C3946 (\69\:gnd! \6\:S12) capacitor c=7.66993e-19
    C3947 (\109\:vdd! I0\|N_S02) capacitor c=4.5816e-19
    C3948 (\8\:net7 \3\:S24) capacitor c=9.80356e-19
    C3949 (\31\:vdd! \32\:vdd!) capacitor c=3.43043e-18
    C3950 (\41\:vdd! \42\:vdd!) capacitor c=3.45504e-18
    C3951 (\86\:vdd! \87\:vdd!) capacitor c=3.59821e-18
    C3952 (\101\:vdd! \102\:vdd!) capacitor c=3.64989e-18
    C3953 (\91\:vdd! \92\:vdd!) capacitor c=3.68614e-18
    C3954 (\9\:vdd! \10\:vdd!) capacitor c=3.82153e-18
    C3955 (\19\:vdd! \20\:vdd!) capacitor c=3.83527e-18
    C3956 (\21\:vdd! vdd!) capacitor c=4.49943e-18
    C3957 (\108\:vdd! \86\:vdd!) capacitor c=4.88179e-18
    C3958 (\51\:vdd! \52\:vdd!) capacitor c=4.89033e-18
    C3959 (\61\:vdd! \62\:vdd!) capacitor c=4.89035e-18
    C3960 (\111\:vdd! vdd!) capacitor c=4.97932e-18
    C3961 (\101\:vdd! vdd!) capacitor c=5.45463e-18
    C3962 (\91\:vdd! vdd!) capacitor c=5.96934e-18
    C3963 (\96\:vdd! \97\:vdd!) capacitor c=6.07313e-18
    C3964 (\4\:vdd! vdd!) capacitor c=6.29795e-18
    C3965 (\26\:vdd! \27\:vdd!) capacitor c=6.29964e-18
    C3966 (\71\:vdd! \72\:vdd!) capacitor c=6.34749e-18
    C3967 (\4\:vdd! \5\:vdd!) capacitor c=6.38382e-18
    C3968 (\81\:vdd! \82\:vdd!) capacitor c=6.39545e-18
    C3969 (\76\:vdd! \77\:vdd!) capacitor c=6.49365e-18
    C3970 (\56\:vdd! \57\:vdd!) capacitor c=6.63221e-18
    C3971 (\66\:vdd! \67\:vdd!) capacitor c=6.68254e-18
    C3972 (\46\:vdd! \47\:vdd!) capacitor c=6.82108e-18
    C3973 (\19\:vdd! vdd!) capacitor c=6.84473e-18
    C3974 (\9\:vdd! vdd!) capacitor c=6.93623e-18
    C3975 (\36\:vdd! \37\:vdd!) capacitor c=7.06418e-18
    C3976 (\14\:vdd! \15\:vdd!) capacitor c=7.1033e-18
    C3977 (\41\:vdd! vdd!) capacitor c=7.28174e-18
    C3978 (\31\:vdd! vdd!) capacitor c=7.3131e-18
    C3979 (\109\:vdd! vdd!) capacitor c=7.66302e-18
    C3980 (\14\:vdd! vdd!) capacitor c=8.04055e-18
    C3981 (\51\:vdd! vdd!) capacitor c=8.22279e-18
    C3982 (\61\:vdd! vdd!) capacitor c=8.32348e-18
    C3983 (\26\:vdd! vdd!) capacitor c=8.75937e-18
    C3984 (\36\:vdd! vdd!) capacitor c=9.02725e-18
    C3985 (\86\:vdd! vdd!) capacitor c=9.02752e-18
    C3986 (\66\:vdd! vdd!) capacitor c=9.64385e-18
    C3987 (\10\:I1\|net10 \3\:I1\|N_S11) capacitor c=4.0135e-19
    C3988 (\8\:I1\|net10 \2\:I1\|N_S11) capacitor c=7.89687e-19
    C3989 (\2\:Y2 I7\|N_S) capacitor c=6.7939e-19
    C3990 (\1\:Y2 \4\:I7\|N_S) capacitor c=7.65365e-19
    C3991 (\2\:net17 \5\:S21) capacitor c=1.08737e-18
    C3992 (\6\:I1\|net3 \2\:I1\|net8) capacitor c=1.57145e-18
    C3993 (\6\:I0\|net6 \6\:S12) capacitor c=6.56356e-19
    C3994 (\10\:I0\|net6 \4\:S12) capacitor c=1.09619e-18
    C3995 (\6\:I0\|net6 \4\:S12) capacitor c=1.14404e-18
    C3996 (\7\:net16 \56\:gnd!) capacitor c=2.11868e-18
    C3997 (\10\:I0\|net10 \5\:S12) capacitor c=8.13955e-19
    C3998 (\8\:I0\|net10 \3\:S12) capacitor c=9.80685e-19
    C3999 (\62\:vdd! \4\:S22) capacitor c=3.364e-19
    C4000 (\76\:vdd! \2\:S22) capacitor c=3.68164e-19
    C4001 (\56\:vdd! \1\:S22) capacitor c=4.84895e-19
    C4002 (\10\:S22 vdd!) capacitor c=8.4045e-19
    C4003 (\7\:S22 vdd!) capacitor c=1.00094e-18
    C4004 (\9\:S22 \76\:vdd!) capacitor c=1.05438e-18
    C4005 (\61\:vdd! \4\:S22) capacitor c=1.18061e-18
    C4006 (\2\:I1\|net10 \3\:I1\|N_S01) capacitor c=6.15661e-19
    C4007 (\4\:net22 \5\:S23) capacitor c=7.60893e-19
    C4008 (\4\:net22 \2\:S23) capacitor c=1.29196e-18
    C4009 (\10\:I1\|net3 \2\:I1\|net3) capacitor c=1.47401e-18
    C4010 (net20 \2\:S33) capacitor c=4.53325e-19
    C4011 (\32\:vdd! \4\:S01) capacitor c=3.37349e-19
    C4012 (\26\:vdd! \1\:S01) capacitor c=3.61035e-19
    C4013 (\46\:vdd! \2\:S01) capacitor c=3.74079e-19
    C4014 (\26\:vdd! \5\:S01) capacitor c=7.00939e-19
    C4015 (\21\:vdd! \5\:S01) capacitor c=7.01679e-19
    C4016 (\7\:net20 \7\:I1\|net3) capacitor c=2.35576e-18
    C4017 (\76\:gnd! \6\:net18) capacitor c=1.2681e-18
    C4018 (\148\:gnd! \9\:net18) capacitor c=1.27353e-18
    C4019 (\9\:net18 \10\:gnd!) capacitor c=1.8483e-18
    C4020 (\2\:net18 \11\:gnd!) capacitor c=1.96088e-18
    C4021 (\111\:gnd! \3\:net20) capacitor c=2.88053e-18
    C4022 (I0\|net10 \2\:I0\|N_S00) capacitor c=7.7685e-19
    C4023 (\51\:vdd! \4\:S12) capacitor c=4.36043e-19
    C4024 (\71\:vdd! \2\:S12) capacitor c=4.74929e-19
    C4025 (\51\:vdd! \1\:S12) capacitor c=4.8377e-19
    C4026 (\51\:vdd! \3\:S12) capacitor c=7.8149e-19
    C4027 (\7\:S12 vdd!) capacitor c=1.00094e-18
    C4028 (\51\:vdd! \6\:S12) capacitor c=1.02403e-18
    C4029 (\51\:vdd! \5\:S12) capacitor c=1.03101e-18
    C4030 (\46\:vdd! \6\:S12) capacitor c=1.14414e-18
    C4031 (\3\:I1\|net6 \7\:S31) capacitor c=8.5641e-19
    C4032 (\2\:net19 \2\:I9\|N_S) capacitor c=8.1386e-19
    C4033 (\3\:I0\|net8 \7\:S12) capacitor c=8.69251e-19
    C4034 (\10\:I0\|net3 \8\:I0\|net1) capacitor c=1.09167e-18
    C4035 (\10\:net5 \139\:gnd!) capacitor c=1.44374e-18
    C4036 (\2\:net7 \116\:gnd!) capacitor c=1.90585e-18
    C4037 (\134\:gnd! \8\:net7) capacitor c=2.07506e-18
    C4038 (\134\:gnd! \7\:net7) capacitor c=2.26165e-18
    C4039 (\3\:Y3 \5\:net20) capacitor c=1.28144e-18
    C4040 (\6\:I0\|net10 \6\:I0\|N_S11) capacitor c=7.19574e-19
    C4041 (\2\:net1 \6\:S11) capacitor c=5.06085e-19
    C4042 (\5\:net1 \3\:S11) capacitor c=1.2853e-18
    C4043 (\7\:I0\|net3 \7\:I0\|net8) capacitor c=1.0191e-18
    C4044 (\6\:I0\|net3 \2\:I0\|net8) capacitor c=1.51156e-18
    C4045 (\14\:vdd! \2\:net3) capacitor c=1.06168e-18
    C4046 (\8\:net3 \5\:vdd!) capacitor c=1.11903e-18
    C4047 (\8\:net3 \27\:vdd!) capacitor c=1.28231e-18
    C4048 (\7\:I8\|N_S \6\:S24) capacitor c=6.42088e-19
    C4049 (\7\:I1\|N_S10 \6\:S31) capacitor c=6.26712e-19
    C4050 (\6\:net5 \3\:Y3) capacitor c=1.31552e-18
    C4051 (\2\:net5 \3\:Y3) capacitor c=1.51569e-18
    C4052 (\36\:vdd! \7\:net1) capacitor c=1.45062e-18
    C4053 (\31\:vdd! \5\:net1) capacitor c=1.5712e-18
    C4054 (\31\:vdd! \4\:net1) capacitor c=1.6289e-18
    C4055 (\51\:vdd! \4\:net1) capacitor c=1.82997e-18
    C4056 (\148\:gnd! \2\:net17) capacitor c=1.36614e-18
    C4057 (\2\:net17 \42\:gnd!) capacitor c=1.52763e-18
    C4058 (\2\:net20 \9\:I1\|N_S12) capacitor c=3.43322e-19
    C4059 (\3\:net20 \2\:I1\|N_S12) capacitor c=5.71772e-19
    C4060 (\4\:net17 I1\|net10) capacitor c=1.16811e-18
    C4061 (\41\:vdd! \7\:net18) capacitor c=1.1291e-18
    C4062 (\2\:net18 vdd!) capacitor c=1.1724e-18
    C4063 (\56\:vdd! \6\:net18) capacitor c=1.23012e-18
    C4064 (\3\:I0\|net2 \2\:I0\|N_S11) capacitor c=5.91944e-19
    C4065 (\3\:I1\|net9 \2\:S21) capacitor c=9.51817e-19
    C4066 (\8\:I1\|net1 \3\:I1\|N_S02) capacitor c=3.95454e-19
    C4067 (\5\:I1\|N_S02 \6\:I1\|net1) capacitor c=4.08087e-19
    C4068 (S12 \5\:I0\|N_S01) capacitor c=5.62664e-19
    C4069 (\6\:S12 \3\:I0\|N_S01) capacitor c=6.39762e-19
    C4070 (\7\:net20 vdd!) capacitor c=1.51008e-18
    C4071 (\4\:gnd! \6\:net2) capacitor c=8.56525e-19
    C4072 (I1\|net3 \2\:I1\|N_S01) capacitor c=5.8475e-19
    C4073 (\6\:I1\|net10 \7\:S21) capacitor c=7.37412e-19
    C4074 (\3\:I1\|net10 \7\:S21) capacitor c=8.69251e-19
    C4075 (\6\:net3 \7\:S01) capacitor c=4.4714e-19
    C4076 (\8\:net3 \5\:S01) capacitor c=5.97122e-19
    C4077 (\158\:gnd! \3\:I3\|N_S) capacitor c=2.52406e-19
    C4078 (I3\|N_S \11\:gnd!) capacitor c=7.6071e-19
    C4079 (\76\:vdd! \2\:net22) capacitor c=1.72917e-18
    C4080 (\6\:net21 \3\:I8\|N_S) capacitor c=5.95369e-19
    C4081 (\2\:net21 \2\:I8\|N_S) capacitor c=8.12514e-19
    C4082 (\7\:net21 \5\:S23) capacitor c=1.41627e-18
    C4083 (\159\:gnd! \4\:net4) capacitor c=1.3394e-18
    C4084 (\6\:net19 \6\:S33) capacitor c=5.67872e-19
    C4085 (\8\:net19 \7\:S33) capacitor c=1.07682e-18
    C4086 (net5 vdd!) capacitor c=2.38236e-18
    C4087 (\86\:vdd! \12\:net5) capacitor c=2.75228e-18
    C4088 (\10\:net5 vdd!) capacitor c=3.22889e-18
    C4089 (\2\:net15 \2\:I1\|N_S10) capacitor c=8.07018e-19
    C4090 (\2\:net22 \2\:I1\|N_S02) capacitor c=5.25882e-19
    C4091 (\4\:net7 vdd!) capacitor c=1.29083e-18
    C4092 (\96\:vdd! \8\:net7) capacitor c=1.33973e-18
    C4093 (\4\:net7 \87\:vdd!) capacitor c=1.72069e-18
    C4094 (\91\:vdd! \2\:net7) capacitor c=2.14647e-18
    C4095 (\3\:net7 vdd!) capacitor c=2.47575e-18
    C4096 (\108\:vdd! \2\:net7) capacitor c=2.81117e-18
    C4097 (\10\:net7 vdd!) capacitor c=2.84095e-18
    C4098 (\8\:net5 \4\:S34) capacitor c=5.46341e-19
    C4099 (\8\:net5 \3\:S34) capacitor c=9.80097e-19
    C4100 (\10\:net5 \2\:S34) capacitor c=1.34283e-18
    C4101 (\134\:gnd! \6\:net19) capacitor c=1.47108e-18
    C4102 (\61\:vdd! \2\:net15) capacitor c=1.14853e-18
    C4103 (\41\:vdd! net15) capacitor c=1.54326e-18
    C4104 (\2\:I1\|net6 \5\:S32) capacitor c=8.65774e-19
    C4105 (\6\:I2\|N_S \1\:S00) capacitor c=5.83307e-19
    C4106 (\7\:net16 \8\:net16) capacitor c=1.05959e-18
    C4107 (\7\:net16 \10\:net16) capacitor c=1.30048e-18
    C4108 (\2\:net16 \3\:net16) capacitor c=1.45701e-18
    C4109 (\2\:net16 \5\:net16) capacitor c=2.17995e-18
    C4110 (\10\:I1\|net3 \2\:I1\|N_S02) capacitor c=5.25026e-19
    C4111 (\7\:I1\|N_S00 \6\:S21) capacitor c=6.38116e-19
    C4112 (\10\:I1\|net10 \5\:S32) capacitor c=8.30671e-19
    C4113 (\8\:I1\|net10 \3\:S32) capacitor c=9.80685e-19
    C4114 (\2\:net16 \2\:net3) capacitor c=1.00097e-18
    C4115 (\7\:I8\|N_S \137\:gnd!) capacitor c=6.17621e-19
    C4116 (\4\:net2 \5\:S11) capacitor c=9.64182e-19
    C4117 (\2\:net2 \3\:S11) capacitor c=9.80685e-19
    C4118 (\4\:net2 \2\:S11) capacitor c=1.25642e-18
    C4119 (\3\:I1\|net8 \7\:S32) capacitor c=8.65339e-19
    C4120 (\140\:gnd! \2\:I7\|N_S) capacitor c=5.29984e-19
    C4121 (\51\:vdd! net2) capacitor c=1.46454e-18
    C4122 (\4\:net17 \3\:I1\|N_S00) capacitor c=5.59492e-19
    C4123 (\2\:net17 \2\:I1\|N_S00) capacitor c=8.1386e-19
    C4124 (\8\:I0\|net1 \3\:I0\|N_S02) capacitor c=4.0135e-19
    C4125 (\5\:I0\|N_S02 \6\:I0\|net1) capacitor c=4.09206e-19
    C4126 (I0\|net3 \2\:I0\|N_S01) capacitor c=5.8475e-19
    C4127 (\6\:S32 \5\:I1\|N_S11) capacitor c=4.81716e-19
    C4128 (\6\:net4 \4\:vdd!) capacitor c=1.12406e-18
    C4129 (\31\:vdd! \2\:net4) capacitor c=1.13237e-18
    C4130 (\46\:vdd! net4) capacitor c=1.23012e-18
    C4131 (\55\:gnd! \3\:I1\|net5) capacitor c=5.14471e-19
    C4132 (\10\:net5 \3\:Y5) capacitor c=1.36252e-18
    C4133 (\3\:I1\|net1 \5\:S23) capacitor c=3.92425e-19
    C4134 (\6\:I1\|net1 \4\:S23) capacitor c=5.46341e-19
    C4135 (\6\:I1\|net1 \3\:S23) capacitor c=9.22978e-19
    C4136 (\3\:I1\|net9 \69\:gnd!) capacitor c=1.14735e-18
    C4137 (\6\:I1\|net3 \3\:S23) capacitor c=1.12308e-18
    C4138 (\101\:vdd! \2\:net19) capacitor c=1.36666e-18
    C4139 (\6\:I1\|net6 \55\:gnd!) capacitor c=5.20363e-19
    C4140 (\148\:gnd! I1\|net6) capacitor c=9.59982e-19
    C4141 (\76\:gnd! \2\:I1\|net6) capacitor c=1.1992e-18
    C4142 (\111\:gnd! \7\:I1\|net6) capacitor c=1.48187e-18
    C4143 (\7\:net18 \9\:net18) capacitor c=1.36831e-18
    C4144 (\7\:I9\|N_S vdd!) capacitor c=6.74871e-19
    C4145 (\96\:vdd! \7\:I9\|N_S) capacitor c=8.49719e-19
    C4146 (\2\:I1\|net8 \5\:S33) capacitor c=8.97386e-19
    C4147 (\10\:I1\|net3 \5\:S33) capacitor c=4.81749e-19
    C4148 (\8\:I1\|net3 \4\:S33) capacitor c=5.09213e-19
    C4149 (\10\:I1\|net3 \2\:S33) capacitor c=9.61326e-19
    C4150 (\8\:I1\|net3 \3\:S33) capacitor c=9.80097e-19
    C4151 (\2\:net16 \8\:net15) capacitor c=1.28843e-18
    C4152 (\6\:I0\|net2 \2\:net7) capacitor c=9.32147e-19
    C4153 (S02 0) capacitor c=2.04665e-17
    C4154 (S30 0) capacitor c=2.52019e-17
    C4155 (S14 0) capacitor c=5.40984e-17
    C4156 (X0 0) capacitor c=3.03158e-17
    C4157 (S13 0) capacitor c=3.96894e-17
    C4158 (S03 0) capacitor c=1.58326e-17
    C4159 (X7 0) capacitor c=2.6086e-17
    C4160 (X6 0) capacitor c=1.20883e-17
    C4161 (X2 0) capacitor c=2.44872e-17
    C4162 (S04 0) capacitor c=2.42815e-17
    C4163 (Y6 0) capacitor c=4.64391e-17
    C4164 (S20 0) capacitor c=2.7165e-17
    C4165 (X4 0) capacitor c=1.06409e-17
    C4166 (Y1 0) capacitor c=5.30448e-17
    C4167 (Y4 0) capacitor c=4.21527e-17
    C4168 (X5 0) capacitor c=2.64547e-17
    C4169 (Y2 0) capacitor c=6.30964e-17
    C4170 (S31 0) capacitor c=4.52458e-17
    C4171 (S10 0) capacitor c=3.20345e-17
    C4172 (Y0 0) capacitor c=2.84089e-17
    C4173 (S21 0) capacitor c=4.22287e-17
    C4174 (S24 0) capacitor c=5.55183e-17
    C4175 (S32 0) capacitor c=2.73668e-17
    C4176 (X3 0) capacitor c=2.306e-17
    C4177 (S23 0) capacitor c=9.28323e-17
    C4178 (S33 0) capacitor c=2.88908e-17
    C4179 (Y3 0) capacitor c=5.37704e-17
    C4180 (Y7 0) capacitor c=5.4292e-17
    C4181 (S11 0) capacitor c=3.91603e-17
    C4182 (vdd! 0) capacitor c=6.45974e-17
    C4183 (S34 0) capacitor c=1.5526e-16
    C4184 (S22 0) capacitor c=1.94011e-17
    C4185 (X1 0) capacitor c=3.56491e-17
    C4186 (S12 0) capacitor c=3.4511e-17
    C4187 (Y5 0) capacitor c=1.36871e-16
    C4188 (\2\:S04 0) capacitor c=1.55458e-17
    C4189 (\2\:S14 0) capacitor c=1.03863e-17
    C4190 (\2\:S24 0) capacitor c=1.45273e-17
    C4191 (\2\:S34 0) capacitor c=7.62397e-18
    C4192 (I6\|N_S 0) capacitor c=3.35258e-19
    C4193 (I7\|N_S 0) capacitor c=3.99863e-19
    C4194 (I8\|N_S 0) capacitor c=9.41575e-19
    C4195 (I9\|N_S 0) capacitor c=8.15213e-19
    C4196 (\1\:S04 0) capacitor c=1.31063e-17
    C4197 (\1\:S14 0) capacitor c=1.08603e-17
    C4198 (\1\:S24 0) capacitor c=7.64409e-18
    C4199 (\1\:S34 0) capacitor c=5.88307e-18
    C4200 (\4\:I6\|N_S 0) capacitor c=1.83596e-19
    C4201 (\4\:I7\|N_S 0) capacitor c=4.96204e-19
    C4202 (\4\:I8\|N_S 0) capacitor c=6.58279e-19
    C4203 (\4\:I9\|N_S 0) capacitor c=8.7724e-19
    C4204 (\5\:S04 0) capacitor c=7.06266e-18
    C4205 (\5\:S14 0) capacitor c=9.03853e-18
    C4206 (\5\:S24 0) capacitor c=9.61184e-18
    C4207 (\5\:S34 0) capacitor c=9.94285e-18
    C4208 (\2\:S03 0) capacitor c=1.30139e-17
    C4209 (\2\:S13 0) capacitor c=1.4346e-17
    C4210 (\2\:S23 0) capacitor c=1.31279e-17
    C4211 (\2\:S33 0) capacitor c=1.1634e-17
    C4212 (I0\|N_S02 0) capacitor c=1.02781e-18
    C4213 (I0\|N_S12 0) capacitor c=5.30637e-19
    C4214 (I1\|N_S02 0) capacitor c=6.09662e-19
    C4215 (I1\|N_S12 0) capacitor c=5.48776e-19
    C4216 (\1\:S03 0) capacitor c=1.14477e-17
    C4217 (\1\:S13 0) capacitor c=1.1118e-17
    C4218 (\1\:S23 0) capacitor c=9.72405e-18
    C4219 (\1\:S33 0) capacitor c=1.23742e-17
    C4220 (\4\:I0\|N_S02 0) capacitor c=4.73334e-19
    C4221 (\4\:I0\|N_S12 0) capacitor c=5.31585e-20
    C4222 (\4\:I1\|N_S02 0) capacitor c=2.55079e-19
    C4223 (\4\:I1\|N_S12 0) capacitor c=5.26649e-19
    C4224 (\5\:S03 0) capacitor c=7.2336e-18
    C4225 (\5\:S13 0) capacitor c=8.17184e-18
    C4226 (\5\:S23 0) capacitor c=7.50845e-18
    C4227 (\5\:S33 0) capacitor c=9.14309e-18
    C4228 (\2\:S02 0) capacitor c=1.88809e-17
    C4229 (\2\:S12 0) capacitor c=1.79204e-17
    C4230 (\2\:S22 0) capacitor c=9.49412e-18
    C4231 (\2\:S32 0) capacitor c=1.56238e-17
    C4232 (I0\|N_S01 0) capacitor c=9.26607e-19
    C4233 (I0\|N_S11 0) capacitor c=8.09937e-19
    C4234 (I1\|N_S01 0) capacitor c=1.614e-18
    C4235 (I1\|N_S11 0) capacitor c=8.92324e-19
    C4236 (\1\:S02 0) capacitor c=1.38676e-17
    C4237 (\1\:S12 0) capacitor c=1.19989e-17
    C4238 (\1\:S22 0) capacitor c=9.66613e-18
    C4239 (\1\:S32 0) capacitor c=1.35181e-17
    C4240 (\4\:I0\|N_S01 0) capacitor c=1.75514e-19
    C4241 (\4\:I0\|N_S11 0) capacitor c=2.0977e-19
    C4242 (\4\:I1\|N_S01 0) capacitor c=2.32487e-19
    C4243 (\4\:I1\|N_S11 0) capacitor c=2.00045e-19
    C4244 (\5\:S02 0) capacitor c=9.15379e-18
    C4245 (\5\:S12 0) capacitor c=9.18593e-18
    C4246 (\5\:S22 0) capacitor c=1.05819e-17
    C4247 (\5\:S32 0) capacitor c=1.02853e-17
    C4248 (\2\:S01 0) capacitor c=1.71037e-17
    C4249 (\2\:S11 0) capacitor c=1.59084e-17
    C4250 (\2\:S21 0) capacitor c=1.23233e-17
    C4251 (\2\:S31 0) capacitor c=1.18533e-17
    C4252 (I0\|N_S00 0) capacitor c=5.2355e-19
    C4253 (I0\|N_S10 0) capacitor c=1.24194e-18
    C4254 (I1\|N_S00 0) capacitor c=9.13246e-19
    C4255 (I1\|N_S10 0) capacitor c=9.96562e-19
    C4256 (\1\:S01 0) capacitor c=1.16077e-17
    C4257 (\1\:S11 0) capacitor c=1.25009e-17
    C4258 (\1\:S21 0) capacitor c=9.07865e-18
    C4259 (\1\:S31 0) capacitor c=1.29249e-17
    C4260 (\4\:I0\|N_S00 0) capacitor c=1.92956e-19
    C4261 (\4\:I0\|N_S10 0) capacitor c=3.65206e-19
    C4262 (\4\:I1\|N_S00 0) capacitor c=4.53372e-19
    C4263 (\4\:I1\|N_S10 0) capacitor c=6.74061e-19
    C4264 (\5\:S01 0) capacitor c=1.0017e-17
    C4265 (\5\:S11 0) capacitor c=1.37647e-17
    C4266 (\5\:S21 0) capacitor c=8.535e-18
    C4267 (\5\:S31 0) capacitor c=1.00241e-17
    C4268 (\2\:S00 0) capacitor c=1.15488e-17
    C4269 (\2\:S10 0) capacitor c=1.43157e-17
    C4270 (\2\:S20 0) capacitor c=9.95072e-18
    C4271 (\2\:S30 0) capacitor c=9.95403e-18
    C4272 (\2\:I3\|N_S 0) capacitor c=4.54742e-19
    C4273 (\2\:I4\|N_S 0) capacitor c=5.67358e-19
    C4274 (\2\:I5\|N_S 0) capacitor c=1.35482e-19
    C4275 (\6\:S00 0) capacitor c=1.13705e-17
    C4276 (\6\:S10 0) capacitor c=8.91332e-18
    C4277 (\6\:S20 0) capacitor c=1.0372e-17
    C4278 (\6\:S30 0) capacitor c=8.27845e-18
    C4279 (\5\:I2\|N_S 0) capacitor c=3.33185e-19
    C4280 (\5\:I3\|N_S 0) capacitor c=6.23405e-19
    C4281 (\5\:I4\|N_S 0) capacitor c=3.14559e-19
    C4282 (\5\:I5\|N_S 0) capacitor c=3.31368e-19
    C4283 (\5\:S00 0) capacitor c=1.80265e-17
    C4284 (\5\:S10 0) capacitor c=1.19665e-17
    C4285 (\5\:S20 0) capacitor c=1.37784e-17
    C4286 (\5\:S30 0) capacitor c=1.35865e-17
    C4287 (\3\:S04 0) capacitor c=5.51604e-17
    C4288 (\3\:S14 0) capacitor c=5.16203e-17
    C4289 (\3\:S24 0) capacitor c=5.47883e-17
    C4290 (\3\:S34 0) capacitor c=5.24611e-17
    C4291 (\2\:I6\|N_S 0) capacitor c=1.50164e-17
    C4292 (\2\:I7\|N_S 0) capacitor c=1.55449e-17
    C4293 (\2\:I8\|N_S 0) capacitor c=1.30738e-17
    C4294 (\2\:I9\|N_S 0) capacitor c=1.23945e-17
    C4295 (\7\:S04 0) capacitor c=6.28648e-18
    C4296 (\7\:S14 0) capacitor c=6.67346e-18
    C4297 (\7\:S24 0) capacitor c=6.63641e-18
    C4298 (\7\:S34 0) capacitor c=7.30732e-18
    C4299 (\3\:I6\|N_S 0) capacitor c=2.10559e-17
    C4300 (\3\:I7\|N_S 0) capacitor c=2.16356e-17
    C4301 (\3\:I8\|N_S 0) capacitor c=1.91028e-17
    C4302 (\3\:I9\|N_S 0) capacitor c=1.8305e-17
    C4303 (\4\:S04 0) capacitor c=6.80277e-17
    C4304 (\4\:S14 0) capacitor c=6.20707e-17
    C4305 (\4\:S24 0) capacitor c=6.13995e-17
    C4306 (\4\:S34 0) capacitor c=5.43519e-17
    C4307 (\3\:S03 0) capacitor c=4.91008e-17
    C4308 (\3\:S13 0) capacitor c=4.76771e-17
    C4309 (\3\:S23 0) capacitor c=4.67201e-17
    C4310 (\3\:S33 0) capacitor c=6.76273e-17
    C4311 (\2\:I0\|N_S02 0) capacitor c=1.46997e-17
    C4312 (\2\:I0\|N_S12 0) capacitor c=1.56634e-17
    C4313 (\2\:I1\|N_S02 0) capacitor c=1.34407e-17
    C4314 (\2\:I1\|N_S12 0) capacitor c=1.23436e-17
    C4315 (\7\:S03 0) capacitor c=6.0994e-18
    C4316 (\7\:S13 0) capacitor c=7.36275e-18
    C4317 (\7\:S23 0) capacitor c=8.54551e-18
    C4318 (\7\:S33 0) capacitor c=6.48141e-18
    C4319 (\3\:I0\|N_S02 0) capacitor c=2.06679e-17
    C4320 (\3\:I0\|N_S12 0) capacitor c=2.12839e-17
    C4321 (\3\:I1\|N_S02 0) capacitor c=1.95511e-17
    C4322 (\3\:I1\|N_S12 0) capacitor c=1.75322e-17
    C4323 (\4\:S03 0) capacitor c=4.74153e-17
    C4324 (\4\:S13 0) capacitor c=4.94729e-17
    C4325 (\4\:S23 0) capacitor c=4.78493e-17
    C4326 (\4\:S33 0) capacitor c=6.84314e-17
    C4327 (\3\:S02 0) capacitor c=5.48882e-17
    C4328 (\3\:S12 0) capacitor c=5.04084e-17
    C4329 (\3\:S22 0) capacitor c=5.03035e-17
    C4330 (\3\:S32 0) capacitor c=6.81041e-17
    C4331 (\2\:I0\|N_S01 0) capacitor c=1.50148e-17
    C4332 (\2\:I0\|N_S11 0) capacitor c=1.49188e-17
    C4333 (\2\:I1\|N_S01 0) capacitor c=1.49295e-17
    C4334 (\2\:I1\|N_S11 0) capacitor c=1.33492e-17
    C4335 (\7\:S02 0) capacitor c=6.2484e-18
    C4336 (\7\:S12 0) capacitor c=7.59384e-18
    C4337 (\7\:S22 0) capacitor c=7.8992e-18
    C4338 (\7\:S32 0) capacitor c=6.98786e-18
    C4339 (\3\:I0\|N_S01 0) capacitor c=2.11506e-17
    C4340 (\3\:I0\|N_S11 0) capacitor c=2.10088e-17
    C4341 (\3\:I1\|N_S01 0) capacitor c=2.11022e-17
    C4342 (\3\:I1\|N_S11 0) capacitor c=1.88835e-17
    C4343 (\4\:S02 0) capacitor c=6.03186e-17
    C4344 (\4\:S12 0) capacitor c=5.71386e-17
    C4345 (\4\:S22 0) capacitor c=5.87022e-17
    C4346 (\4\:S32 0) capacitor c=6.8795e-17
    C4347 (\3\:S01 0) capacitor c=5.9119e-17
    C4348 (\3\:S11 0) capacitor c=5.54414e-17
    C4349 (\3\:S21 0) capacitor c=5.65894e-17
    C4350 (\3\:S31 0) capacitor c=6.77317e-17
    C4351 (\2\:I0\|N_S00 0) capacitor c=1.31049e-17
    C4352 (\2\:I0\|N_S10 0) capacitor c=1.58315e-17
    C4353 (\2\:I1\|N_S00 0) capacitor c=1.30009e-17
    C4354 (\2\:I1\|N_S10 0) capacitor c=1.36726e-17
    C4355 (\7\:S01 0) capacitor c=6.18259e-18
    C4356 (\7\:S11 0) capacitor c=7.34669e-18
    C4357 (\7\:S21 0) capacitor c=7.17573e-18
    C4358 (\7\:S31 0) capacitor c=6.93198e-18
    C4359 (\3\:I0\|N_S00 0) capacitor c=2.0852e-17
    C4360 (\3\:I0\|N_S10 0) capacitor c=2.03552e-17
    C4361 (\3\:I1\|N_S00 0) capacitor c=2.03098e-17
    C4362 (\3\:I1\|N_S10 0) capacitor c=1.88806e-17
    C4363 (\4\:S01 0) capacitor c=6.13014e-17
    C4364 (\4\:S11 0) capacitor c=6.09058e-17
    C4365 (\4\:S21 0) capacitor c=6.17374e-17
    C4366 (\4\:S31 0) capacitor c=7.48204e-17
    C4367 (\3\:S00 0) capacitor c=5.79437e-17
    C4368 (\3\:S10 0) capacitor c=5.67088e-17
    C4369 (\3\:S20 0) capacitor c=6.44818e-17
    C4370 (\3\:S30 0) capacitor c=7.60563e-17
    C4371 (\3\:I2\|N_S 0) capacitor c=2.0404e-17
    C4372 (\3\:I3\|N_S 0) capacitor c=1.95961e-17
    C4373 (\3\:I4\|N_S 0) capacitor c=2.06583e-17
    C4374 (\3\:I5\|N_S 0) capacitor c=1.89291e-17
    C4375 (\7\:S00 0) capacitor c=7.02228e-18
    C4376 (\7\:S10 0) capacitor c=5.91145e-18
    C4377 (\7\:S20 0) capacitor c=6.45187e-18
    C4378 (\7\:S30 0) capacitor c=6.67606e-18
    C4379 (\4\:I2\|N_S 0) capacitor c=1.50617e-17
    C4380 (\4\:I3\|N_S 0) capacitor c=1.63473e-17
    C4381 (\4\:I4\|N_S 0) capacitor c=1.56881e-17
    C4382 (\4\:I5\|N_S 0) capacitor c=1.39795e-17
    C4383 (\4\:S00 0) capacitor c=5.24023e-17
    C4384 (\4\:S10 0) capacitor c=5.71428e-17
    C4385 (\4\:S20 0) capacitor c=5.41742e-17
    C4386 (\4\:S30 0) capacitor c=6.89773e-17
    C4387 (\5\:I6\|N_S 0) capacitor c=1.72163e-17
    C4388 (\5\:I7\|N_S 0) capacitor c=1.90295e-17
    C4389 (\5\:I8\|N_S 0) capacitor c=2.42867e-17
    C4390 (\5\:I9\|N_S 0) capacitor c=2.05433e-17
    C4391 (\6\:S04 0) capacitor c=3.26422e-17
    C4392 (\6\:S14 0) capacitor c=4.27039e-17
    C4393 (\6\:S24 0) capacitor c=3.39385e-17
    C4394 (\6\:S34 0) capacitor c=4.22917e-17
    C4395 (\5\:I0\|N_S02 0) capacitor c=3.45401e-17
    C4396 (\5\:I0\|N_S12 0) capacitor c=1.80418e-17
    C4397 (\5\:I1\|N_S02 0) capacitor c=1.26363e-17
    C4398 (\5\:I1\|N_S12 0) capacitor c=1.79321e-17
    C4399 (\6\:S03 0) capacitor c=3.13044e-17
    C4400 (\6\:S13 0) capacitor c=5.27779e-17
    C4401 (\6\:S23 0) capacitor c=6.76488e-17
    C4402 (\6\:S33 0) capacitor c=4.96845e-17
    C4403 (\5\:I0\|N_S01 0) capacitor c=3.91431e-17
    C4404 (\5\:I0\|N_S11 0) capacitor c=1.26612e-17
    C4405 (\5\:I1\|N_S01 0) capacitor c=2.87078e-17
    C4406 (\5\:I1\|N_S11 0) capacitor c=1.14258e-17
    C4407 (\6\:S02 0) capacitor c=3.05816e-17
    C4408 (\6\:S12 0) capacitor c=5.2539e-17
    C4409 (\6\:S22 0) capacitor c=3.10076e-17
    C4410 (\6\:S32 0) capacitor c=4.4979e-17
    C4411 (\5\:I0\|N_S00 0) capacitor c=1.45895e-17
    C4412 (\5\:I0\|N_S10 0) capacitor c=2.02678e-17
    C4413 (\5\:I1\|N_S00 0) capacitor c=2.28582e-17
    C4414 (\5\:I1\|N_S10 0) capacitor c=2.25655e-17
    C4415 (\6\:S01 0) capacitor c=4.48278e-17
    C4416 (\6\:S11 0) capacitor c=4.71362e-17
    C4417 (\6\:S21 0) capacitor c=6.76107e-17
    C4418 (\6\:S31 0) capacitor c=5.20928e-17
    C4419 (\1\:S00 0) capacitor c=4.55573e-17
    C4420 (\1\:S10 0) capacitor c=3.28471e-17
    C4421 (\1\:S20 0) capacitor c=4.53119e-17
    C4422 (\1\:S30 0) capacitor c=3.62009e-17
    C4423 (I2\|N_S 0) capacitor c=1.53996e-17
    C4424 (I3\|N_S 0) capacitor c=2.30744e-17
    C4425 (I4\|N_S 0) capacitor c=3.30982e-17
    C4426 (I5\|N_S 0) capacitor c=2.57792e-17
    C4427 (\12\:net5 0) capacitor c=1.17212e-16
    C4428 (\8\:net22 0) capacitor c=9.63408e-17
    C4429 (\10\:S22 0) capacitor c=4.18679e-17
    C4430 (\4\:Y4 0) capacitor c=2.58149e-17
    C4431 (\7\:Y7 0) capacitor c=2.31271e-17
    C4432 (\13\:net5 0) capacitor c=4.98972e-17
    C4433 (\4\:Y0 0) capacitor c=3.61902e-17
    C4434 (\6\:Y7 0) capacitor c=7.0068e-18
    C4435 (\4\:Y6 0) capacitor c=2.69292e-17
    C4436 (\4\:Y2 0) capacitor c=1.80278e-17
    C4437 (\7\:net7 0) capacitor c=1.14899e-16
    C4438 (\2\:Y0 0) capacitor c=5.97536e-18
    C4439 (\2\:Y2 0) capacitor c=1.1943e-17
    C4440 (\2\:Y4 0) capacitor c=8.21185e-18
    C4441 (\2\:Y6 0) capacitor c=1.1564e-17
    C4442 (\10\:net5 0) capacitor c=7.45774e-17
    C4443 (\91\:vdd! 0) capacitor c=5.65966e-18
    C4444 (\86\:vdd! 0) capacitor c=2.90181e-17
    C4445 (\96\:vdd! 0) capacitor c=4.66797e-17
    C4446 (\101\:vdd! 0) capacitor c=6.33827e-18
    C4447 (\7\:net20 0) capacitor c=2.16375e-16
    C4448 (\4\:net7 0) capacitor c=1.4122e-16
    C4449 (\6\:net5 0) capacitor c=4.87435e-18
    C4450 (\4\:net22 0) capacitor c=2.9475e-17
    C4451 (\8\:I0\|net2 0) capacitor c=2.10998e-17
    C4452 (\10\:I0\|net8 0) capacitor c=5.91135e-18
    C4453 (\8\:I1\|net2 0) capacitor c=2.00882e-17
    C4454 (\10\:I1\|net8 0) capacitor c=1.16336e-17
    C4455 (\2\:net20 0) capacitor c=4.87431e-18
    C4456 (\8\:I0\|net1 0) capacitor c=3.69565e-18
    C4457 (\10\:I0\|net3 0) capacitor c=2.33331e-17
    C4458 (\8\:I1\|net1 0) capacitor c=4.44105e-18
    C4459 (\10\:I1\|net3 0) capacitor c=2.14841e-17
    C4460 (\66\:vdd! 0) capacitor c=1.32924e-18
    C4461 (\76\:vdd! 0) capacitor c=2.36563e-18
    C4462 (\71\:vdd! 0) capacitor c=5.12747e-18
    C4463 (\81\:vdd! 0) capacitor c=5.71177e-18
    C4464 (\6\:I0\|net3 0) capacitor c=3.16845e-17
    C4465 (\6\:I0\|net8 0) capacitor c=8.28754e-18
    C4466 (\6\:I1\|net3 0) capacitor c=3.09647e-17
    C4467 (\6\:I1\|net8 0) capacitor c=1.51582e-17
    C4468 (\8\:I0\|net5 0) capacitor c=1.73617e-17
    C4469 (\10\:I0\|net6 0) capacitor c=5.07187e-18
    C4470 (\8\:I1\|net5 0) capacitor c=1.83637e-17
    C4471 (\10\:I1\|net6 0) capacitor c=1.15912e-17
    C4472 (\3\:I0\|net1 0) capacitor c=1.64967e-17
    C4473 (\3\:I0\|net2 0) capacitor c=2.28658e-17
    C4474 (\3\:I1\|net1 0) capacitor c=1.39316e-17
    C4475 (\3\:I1\|net2 0) capacitor c=2.75035e-17
    C4476 (\8\:I0\|net9 0) capacitor c=2.65837e-18
    C4477 (\10\:I0\|net10 0) capacitor c=8.68142e-18
    C4478 (\8\:I1\|net9 0) capacitor c=8.06153e-18
    C4479 (\10\:I1\|net10 0) capacitor c=7.98242e-18
    C4480 (\46\:vdd! 0) capacitor c=2.56774e-18
    C4481 (\51\:vdd! 0) capacitor c=6.72787e-18
    C4482 (\56\:vdd! 0) capacitor c=2.12622e-18
    C4483 (\61\:vdd! 0) capacitor c=8.42839e-18
    C4484 (\9\:S22 0) capacitor c=4.894e-17
    C4485 (\6\:I0\|net10 0) capacitor c=1.54893e-17
    C4486 (\6\:I0\|net6 0) capacitor c=9.29504e-18
    C4487 (\6\:I1\|net10 0) capacitor c=2.07129e-17
    C4488 (\6\:I1\|net6 0) capacitor c=1.67274e-17
    C4489 (\8\:net3 0) capacitor c=6.47769e-17
    C4490 (\7\:net1 0) capacitor c=2.46912e-17
    C4491 (\3\:I0\|net9 0) capacitor c=9.0775e-18
    C4492 (\3\:I0\|net5 0) capacitor c=1.50841e-17
    C4493 (\3\:I1\|net9 0) capacitor c=7.01433e-18
    C4494 (\3\:I1\|net5 0) capacitor c=1.19754e-17
    C4495 (\9\:net18 0) capacitor c=5.04621e-17
    C4496 (\7\:net16 0) capacitor c=4.26343e-17
    C4497 (\26\:vdd! 0) capacitor c=6.99471e-19
    C4498 (\31\:vdd! 0) capacitor c=6.25244e-18
    C4499 (\36\:vdd! 0) capacitor c=3.12213e-18
    C4500 (\41\:vdd! 0) capacitor c=5.9971e-18
    C4501 (\21\:vdd! 0) capacitor c=7.14087e-18
    C4502 (\22\:vdd! 0) capacitor c=1.26215e-17
    C4503 (\9\:vdd! 0) capacitor c=3.39677e-18
    C4504 (\19\:vdd! 0) capacitor c=1.14614e-17
    C4505 (\4\:vdd! 0) capacitor c=1.1328e-18
    C4506 (\14\:vdd! 0) capacitor c=8.15686e-18
    C4507 (\2\:net18 0) capacitor c=4.22249e-17
    C4508 (\2\:net1 0) capacitor c=4.11034e-17
    C4509 (\4\:net3 0) capacitor c=3.74046e-17
    C4510 (\5\:X0 0) capacitor c=1.55103e-17
    C4511 (\5\:X2 0) capacitor c=8.70664e-18
    C4512 (\5\:X4 0) capacitor c=1.77091e-17
    C4513 (\5\:X6 0) capacitor c=1.09077e-17
    C4514 (\2\:net16 0) capacitor c=6.02326e-17
    C4515 (\1\:X4 0) capacitor c=3.28523e-17
    C4516 (\1\:X2 0) capacitor c=1.55145e-17
    C4517 (\1\:X6 0) capacitor c=2.93723e-17
    C4518 (\1\:X0 0) capacitor c=1.8653e-17
    C4519 (\5\:Y3 0) capacitor c=7.22916e-20
    C4520 (\5\:Y5 0) capacitor c=2.30335e-19
    C4521 (\5\:Y7 0) capacitor c=7.47582e-19
    C4522 (\6\:net22 0) capacitor c=1.55463e-17
    C4523 (\5\:net20 0) capacitor c=4.60986e-16
    C4524 (\2\:net21 0) capacitor c=3.12387e-17
    C4525 (\2\:net19 0) capacitor c=2.4673e-17
    C4526 (\1\:Y0 0) capacitor c=1.69308e-19
    C4527 (\1\:Y2 0) capacitor c=1.92746e-18
    C4528 (\1\:Y4 0) capacitor c=6.03882e-18
    C4529 (\1\:Y6 0) capacitor c=3.46176e-18
    C4530 (\4\:net8 0) capacitor c=4.87417e-17
    C4531 (\4\:net6 0) capacitor c=2.55388e-17
    C4532 (\10\:net7 0) capacitor c=2.06892e-18
    C4533 (\11\:net5 0) capacitor c=1.16141e-19
    C4534 (\2\:Y1 0) capacitor c=9.41566e-18
    C4535 (\6\:Y3 0) capacitor c=1.00451e-17
    C4536 (\4\:Y5 0) capacitor c=6.81748e-18
    C4537 (\4\:Y7 0) capacitor c=8.49639e-18
    C4538 (\87\:vdd! 0) capacitor c=2.51497e-18
    C4539 (\92\:vdd! 0) capacitor c=9.53443e-19
    C4540 (\97\:vdd! 0) capacitor c=6.87093e-19
    C4541 (\102\:vdd! 0) capacitor c=1.42201e-18
    C4542 (\7\:I6\|N_S 0) capacitor c=1.07744e-17
    C4543 (\7\:I7\|N_S 0) capacitor c=9.30889e-18
    C4544 (\7\:I8\|N_S 0) capacitor c=1.07372e-17
    C4545 (\7\:I9\|N_S 0) capacitor c=5.78146e-18
    C4546 (\5\:net7 0) capacitor c=1.30815e-23
    C4547 (\5\:net5 0) capacitor c=2.2024e-19
    C4548 (\4\:net21 0) capacitor c=1.30815e-23
    C4549 (\4\:net19 0) capacitor c=2.05748e-19
    C4550 (\5\:I0\|net2 0) capacitor c=1.80222e-18
    C4551 (\7\:I0\|net8 0) capacitor c=3.21254e-18
    C4552 (\5\:I1\|net2 0) capacitor c=3.62634e-18
    C4553 (\7\:I1\|net8 0) capacitor c=8.49064e-18
    C4554 (\6\:net8 0) capacitor c=4.65146e-17
    C4555 (\6\:net6 0) capacitor c=3.85576e-17
    C4556 (\2\:net22 0) capacitor c=6.55713e-18
    C4557 (net20 0) capacitor c=9.41775e-18
    C4558 (\9\:I0\|net1 0) capacitor c=2.90352e-20
    C4559 (\11\:I0\|net3 0) capacitor c=3.0838e-19
    C4560 (\9\:I1\|net1 0) capacitor c=2.90352e-20
    C4561 (\11\:I1\|net3 0) capacitor c=1.6298e-19
    C4562 (\3\:net7 0) capacitor c=2.66295e-17
    C4563 (net5 0) capacitor c=1.45352e-17
    C4564 (\7\:net21 0) capacitor c=2.2851e-17
    C4565 (\7\:net19 0) capacitor c=1.66049e-17
    C4566 (\67\:vdd! 0) capacitor c=5.13237e-19
    C4567 (\72\:vdd! 0) capacitor c=5.10682e-19
    C4568 (\77\:vdd! 0) capacitor c=5.27918e-19
    C4569 (\82\:vdd! 0) capacitor c=8.60552e-19
    C4570 (\7\:I0\|N_S02 0) capacitor c=1.42289e-17
    C4571 (\7\:I0\|N_S12 0) capacitor c=9.97376e-18
    C4572 (\7\:I1\|N_S02 0) capacitor c=9.3394e-18
    C4573 (\7\:I1\|N_S12 0) capacitor c=4.97444e-18
    C4574 (\5\:I0\|net3 0) capacitor c=2.24392e-19
    C4575 (\5\:I0\|net8 0) capacitor c=1.30815e-23
    C4576 (\5\:I1\|net3 0) capacitor c=5.52048e-19
    C4577 (\5\:I1\|net8 0) capacitor c=1.30815e-23
    C4578 (\5\:I0\|net5 0) capacitor c=2.98183e-18
    C4579 (\7\:I0\|net6 0) capacitor c=7.3706e-18
    C4580 (\5\:I1\|net5 0) capacitor c=6.68049e-18
    C4581 (\7\:I1\|net6 0) capacitor c=6.9429e-18
    C4582 (\9\:I0\|net9 0) capacitor c=2.90352e-20
    C4583 (\11\:I0\|net10 0) capacitor c=2.32939e-19
    C4584 (\9\:I1\|net9 0) capacitor c=2.90352e-20
    C4585 (\11\:I1\|net10 0) capacitor c=2.19007e-19
    C4586 (I0\|net3 0) capacitor c=1.60037e-17
    C4587 (I0\|net8 0) capacitor c=2.9372e-17
    C4588 (I1\|net3 0) capacitor c=1.47397e-17
    C4589 (I1\|net8 0) capacitor c=1.76322e-17
    C4590 (\47\:vdd! 0) capacitor c=1.55082e-19
    C4591 (\52\:vdd! 0) capacitor c=6.3463e-19
    C4592 (\57\:vdd! 0) capacitor c=1.39539e-18
    C4593 (\62\:vdd! 0) capacitor c=6.5223e-19
    C4594 (\7\:I0\|N_S01 0) capacitor c=1.49011e-17
    C4595 (\6\:I0\|N_S11 0) capacitor c=8.49848e-18
    C4596 (\7\:I1\|N_S01 0) capacitor c=1.80533e-17
    C4597 (\6\:I1\|N_S11 0) capacitor c=4.06226e-18
    C4598 (\5\:I0\|net10 0) capacitor c=2.29009e-19
    C4599 (\5\:I0\|net6 0) capacitor c=4.33302e-19
    C4600 (\5\:I1\|net10 0) capacitor c=2.98094e-19
    C4601 (\5\:I1\|net6 0) capacitor c=4.33312e-19
    C4602 (\6\:net3 0) capacitor c=2.61827e-18
    C4603 (\4\:net1 0) capacitor c=4.28821e-18
    C4604 (\2\:net17 0) capacitor c=4.46542e-17
    C4605 (\2\:net15 0) capacitor c=2.59209e-17
    C4606 (\4\:net4 0) capacitor c=6.76307e-17
    C4607 (\4\:net2 0) capacitor c=2.50253e-17
    C4608 (\10\:net18 0) capacitor c=1.35072e-18
    C4609 (\10\:net16 0) capacitor c=8.23903e-18
    C4610 (I0\|net10 0) capacitor c=1.52006e-17
    C4611 (I0\|net6 0) capacitor c=2.5489e-17
    C4612 (I1\|net10 0) capacitor c=1.64842e-17
    C4613 (I1\|net6 0) capacitor c=1.47917e-17
    C4614 (\32\:vdd! 0) capacitor c=9.91541e-20
    C4615 (\37\:vdd! 0) capacitor c=2.44551e-19
    C4616 (\42\:vdd! 0) capacitor c=9.97155e-20
    C4617 (\7\:I0\|N_S00 0) capacitor c=7.11589e-18
    C4618 (\7\:I0\|N_S10 0) capacitor c=1.02968e-17
    C4619 (\7\:I1\|N_S00 0) capacitor c=7.2785e-18
    C4620 (\7\:I1\|N_S10 0) capacitor c=5.53763e-18
    C4621 (\6\:I2\|N_S 0) capacitor c=7.0674e-18
    C4622 (\6\:I3\|N_S 0) capacitor c=8.49165e-18
    C4623 (\6\:I4\|N_S 0) capacitor c=1.49526e-17
    C4624 (\6\:I5\|N_S 0) capacitor c=9.70433e-18
    C4625 (\10\:vdd! 0) capacitor c=8.20599e-19
    C4626 (\15\:vdd! 0) capacitor c=5.55825e-19
    C4627 (\20\:vdd! 0) capacitor c=1.82218e-18
    C4628 (net18 0) capacitor c=3.98141e-18
    C4629 (net16 0) capacitor c=1.29807e-17
    C4630 (\7\:net17 0) capacitor c=5.52529e-18
    C4631 (\7\:net15 0) capacitor c=6.66875e-18
    C4632 (\2\:X0 0) capacitor c=4.01093e-18
    C4633 (\2\:X2 0) capacitor c=4.74339e-18
    C4634 (\2\:X4 0) capacitor c=2.21234e-18
    C4635 (\2\:X6 0) capacitor c=6.6886e-18
    C4636 (\6\:net4 0) capacitor c=6.59195e-17
    C4637 (\6\:net2 0) capacitor c=2.82851e-17
    C4638 (\2\:net3 0) capacitor c=1.36997e-18
    C4639 (\2\:X1 0) capacitor c=1.67061e-17
    C4640 (\2\:X3 0) capacitor c=9.21636e-18
    C4641 (\2\:X5 0) capacitor c=1.3445e-17
    C4642 (\2\:X7 0) capacitor c=1.03738e-17
    C4643 (net8 0) capacitor c=6.25671e-18
    C4644 (net6 0) capacitor c=4.75412e-18
    C4645 (\6\:net7 0) capacitor c=2.46767e-18
    C4646 (\7\:net5 0) capacitor c=5.21831e-18
    C4647 (\4\:Y1 0) capacitor c=2.36453e-18
    C4648 (\1\:Y3 0) capacitor c=1.6997e-18
    C4649 (\1\:Y5 0) capacitor c=2.19171e-18
    C4650 (\1\:Y7 0) capacitor c=6.36754e-19
    C4651 (\5\:net22 0) capacitor c=1.8573e-18
    C4652 (\4\:net20 0) capacitor c=3.51445e-18
    C4653 (net21 0) capacitor c=3.50218e-18
    C4654 (net19 0) capacitor c=1.60769e-18
    C4655 (\3\:Y0 0) capacitor c=1.43407e-18
    C4656 (\3\:Y2 0) capacitor c=1.12868e-18
    C4657 (\3\:Y4 0) capacitor c=1.42416e-18
    C4658 (\3\:Y6 0) capacitor c=1.83225e-19
    C4659 (\2\:net8 0) capacitor c=1.07475e-17
    C4660 (\2\:net6 0) capacitor c=7.56255e-18
    C4661 (\8\:net7 0) capacitor c=6.77318e-18
    C4662 (\8\:net5 0) capacitor c=8.81962e-18
    C4663 (\9\:I6\|N_S 0) capacitor c=1.02164e-17
    C4664 (\9\:I7\|N_S 0) capacitor c=9.93966e-18
    C4665 (\9\:I8\|N_S 0) capacitor c=1.01209e-17
    C4666 (\9\:I9\|N_S 0) capacitor c=2.05348e-18
    C4667 (\5\:I0\|net1 0) capacitor c=3.23934e-18
    C4668 (\7\:I0\|net3 0) capacitor c=5.33981e-18
    C4669 (\5\:I1\|net1 0) capacitor c=3.7816e-18
    C4670 (\7\:I1\|net3 0) capacitor c=4.88388e-18
    C4671 (net7 0) capacitor c=1.45393e-18
    C4672 (\3\:net5 0) capacitor c=1.54583e-18
    C4673 (\8\:net21 0) capacitor c=2.53262e-18
    C4674 (\8\:net19 0) capacitor c=1.99382e-18
    C4675 (\6\:I0\|net2 0) capacitor c=1.61218e-18
    C4676 (\8\:I0\|net8 0) capacitor c=2.56987e-18
    C4677 (\6\:I1\|net2 0) capacitor c=2.54389e-18
    C4678 (\8\:I1\|net8 0) capacitor c=1.37766e-18
    C4679 (\8\:net8 0) capacitor c=9.00381e-18
    C4680 (\8\:net6 0) capacitor c=1.44911e-18
    C4681 (net22 0) capacitor c=9.40021e-18
    C4682 (\3\:net20 0) capacitor c=1.69898e-19
    C4683 (\6\:I0\|net1 0) capacitor c=6.13224e-18
    C4684 (\8\:I0\|net3 0) capacitor c=8.62567e-18
    C4685 (\6\:I1\|net1 0) capacitor c=6.15063e-18
    C4686 (\8\:I1\|net3 0) capacitor c=6.75185e-18
    C4687 (\9\:I0\|N_S02 0) capacitor c=3.3973e-18
    C4688 (\9\:I0\|N_S12 0) capacitor c=7.71843e-18
    C4689 (\9\:I1\|N_S02 0) capacitor c=8.96477e-18
    C4690 (\9\:I1\|N_S12 0) capacitor c=1.70415e-18
    C4691 (\5\:I0\|net9 0) capacitor c=3.30697e-18
    C4692 (\7\:I0\|net10 0) capacitor c=6.09035e-18
    C4693 (\5\:I1\|net9 0) capacitor c=3.6394e-18
    C4694 (\7\:I1\|net10 0) capacitor c=3.54677e-18
    C4695 (\3\:I0\|net3 0) capacitor c=1.62338e-18
    C4696 (\3\:I0\|net8 0) capacitor c=1.89146e-18
    C4697 (\3\:I1\|net3 0) capacitor c=2.49263e-18
    C4698 (\3\:I1\|net8 0) capacitor c=9.88444e-19
    C4699 (\6\:I0\|net5 0) capacitor c=1.39104e-18
    C4700 (\8\:I0\|net6 0) capacitor c=2.31441e-18
    C4701 (\6\:I1\|net5 0) capacitor c=1.39104e-18
    C4702 (\8\:I1\|net6 0) capacitor c=2.29886e-18
    C4703 (\4\:I0\|net1 0) capacitor c=6.16724e-18
    C4704 (\4\:I0\|net2 0) capacitor c=6.34846e-18
    C4705 (\4\:I1\|net1 0) capacitor c=6.16724e-18
    C4706 (\4\:I1\|net2 0) capacitor c=6.68686e-18
    C4707 (\6\:I0\|net9 0) capacitor c=5.08452e-18
    C4708 (\8\:I0\|net10 0) capacitor c=8.47886e-18
    C4709 (\6\:I1\|net9 0) capacitor c=5.084e-18
    C4710 (\8\:I1\|net10 0) capacitor c=6.68121e-18
    C4711 (\9\:I0\|N_S01 0) capacitor c=2.06666e-18
    C4712 (\8\:I0\|N_S11 0) capacitor c=7.75092e-18
    C4713 (\9\:I1\|N_S01 0) capacitor c=9.56533e-18
    C4714 (\8\:I1\|N_S11 0) capacitor c=1.442e-18
    C4715 (net4 0) capacitor c=3.12909e-18
    C4716 (net2 0) capacitor c=4.79104e-18
    C4717 (\6\:net18 0) capacitor c=3.2938e-18
    C4718 (\6\:net16 0) capacitor c=5.15536e-18
    C4719 (\3\:I0\|net10 0) capacitor c=1.57068e-18
    C4720 (\3\:I0\|net6 0) capacitor c=1.77966e-18
    C4721 (\3\:I1\|net10 0) capacitor c=1.57068e-18
    C4722 (\3\:I1\|net6 0) capacitor c=8.556e-19
    C4723 (\5\:net3 0) capacitor c=1.67218e-18
    C4724 (\5\:net1 0) capacitor c=2.04169e-18
    C4725 (net17 0) capacitor c=1.67218e-18
    C4726 (net15 0) capacitor c=1.87282e-18
    C4727 (\4\:I0\|net9 0) capacitor c=1.52814e-18
    C4728 (\4\:I0\|net5 0) capacitor c=1.83769e-18
    C4729 (\4\:I1\|net9 0) capacitor c=1.52717e-18
    C4730 (\4\:I1\|net5 0) capacitor c=1.7132e-18
    C4731 (\2\:net4 0) capacitor c=5.27069e-18
    C4732 (\2\:net2 0) capacitor c=6.79108e-18
    C4733 (\7\:net18 0) capacitor c=6.31994e-18
    C4734 (\8\:net16 0) capacitor c=2.26753e-18
    C4735 (\9\:I0\|N_S00 0) capacitor c=8.87916e-18
    C4736 (\9\:I0\|N_S10 0) capacitor c=1.10611e-17
    C4737 (\9\:I1\|N_S00 0) capacitor c=9.16956e-18
    C4738 (\9\:I1\|N_S10 0) capacitor c=2.42605e-18
    C4739 (\9\:I2\|N_S 0) capacitor c=3.4326e-18
    C4740 (\9\:I3\|N_S 0) capacitor c=1.25161e-17
    C4741 (\9\:I4\|N_S 0) capacitor c=3.79995e-18
    C4742 (\9\:I5\|N_S 0) capacitor c=5.00672e-18
    C4743 (\3\:X0 0) capacitor c=6.67004e-18
    C4744 (\3\:X2 0) capacitor c=7.12787e-18
    C4745 (\3\:X4 0) capacitor c=6.01995e-18
    C4746 (\3\:X6 0) capacitor c=7.03358e-18
    C4747 (\8\:net4 0) capacitor c=6.71019e-18
    C4748 (\8\:net2 0) capacitor c=4.39421e-18
    C4749 (net3 0) capacitor c=1.74302e-18
    C4750 (net1 0) capacitor c=1.55362e-18
    C4751 (\1\:X1 0) capacitor c=8.75899e-19
    C4752 (\1\:X3 0) capacitor c=2.39682e-18
    C4753 (\1\:X5 0) capacitor c=4.79857e-18
    C4754 (\1\:X7 0) capacitor c=1.05457e-18
    C4755 (\5\:net18 0) capacitor c=8.06301e-19
    C4756 (\5\:net16 0) capacitor c=8.06301e-19
    C4757 (\8\:net17 0) capacitor c=5.61411e-19
    C4758 (\8\:net15 0) capacitor c=6.93758e-19
    C4759 (\6\:X2 0) capacitor c=3.46229e-19
    C4760 (\6\:X6 0) capacitor c=4.69134e-19
    C4761 (\7\:X2 0) capacitor c=7.80129e-19
    C4762 (\3\:net16 0) capacitor c=1.22119e-17
    C4763 (\3\:net18 0) capacitor c=3.27279e-17
    C4764 (\4\:net17 0) capacitor c=3.14534e-17
    C4765 (\5\:net17 0) capacitor c=2.86108e-17
    C4766 (\4\:net15 0) capacitor c=5.79127e-17
    C4767 (\5\:net15 0) capacitor c=3.49704e-17
    C4768 (\2\:I0\|net10 0) capacitor c=2.30438e-17
    C4769 (\2\:I0\|net6 0) capacitor c=3.03523e-17
    C4770 (\2\:I1\|net10 0) capacitor c=3.30604e-17
    C4771 (\2\:I1\|net6 0) capacitor c=2.94269e-17
    C4772 (\2\:I0\|net3 0) capacitor c=2.29249e-17
    C4773 (\2\:I0\|net8 0) capacitor c=3.84605e-17
    C4774 (\2\:I1\|net3 0) capacitor c=2.9585e-17
    C4775 (\2\:I1\|net8 0) capacitor c=3.57943e-17
    C4776 (\2\:net7 0) capacitor c=2.22879e-17
    C4777 (\2\:net5 0) capacitor c=2.03061e-17
    C4778 (\6\:net21 0) capacitor c=5.81114e-17
    C4779 (\6\:net19 0) capacitor c=5.36684e-17
    C4780 (\2\:Y3 0) capacitor c=5.69984e-18
    C4781 (\3\:Y3 0) capacitor c=1.55711e-17
    C4782 (\2\:Y7 0) capacitor c=7.9399e-18
    C4783 (\3\:Y7 0) capacitor c=1.56343e-17
    C4784 (\2\:Y5 0) capacitor c=9.18365e-17
    C4785 (\3\:Y5 0) capacitor c=8.88531e-17
    C4786 (\1\:Y1 0) capacitor c=2.61214e-17
    C4787 (\3\:Y1 0) capacitor c=8.49179e-18
    C4788 (\108\:vdd! 0) capacitor c=9.65777e-18
    C4789 (\109\:vdd! 0) capacitor c=1.35822e-17
    C4790 (\111\:vdd! 0) capacitor c=1.02242e-17
    Rj1 (\5\:X0 \1\:X0) resistor r=1.3068 w=1e-07 c=0
    Rj2 (\5\:X2 \1\:X2) resistor r=1.2795 w=9e-08 c=0
    Rj3 (\5\:X4 \1\:X4) resistor r=1.2698 w=1e-07 c=0
    Rj4 (\5\:X6 \1\:X6) resistor r=1.2747 w=1e-07 c=0
    Rj5 (\9\:vdd! \22\:vdd!) resistor r=1.5047 w=1e-07 c=0
    Rj6 (\7\:net16 \2\:net16) resistor r=4.266 w=9e-08 c=0
    Rj7 (\9\:net18 \2\:net18) resistor r=3.6424 w=9e-08 c=0
    Rj8 (\7\:net1 \2\:net1) resistor r=5.9337 w=8e-08 c=0
    Rj9 (\4\:net3 \8\:net3) resistor r=4.5612 w=9e-08 c=0
    Rj10 (\8\:I0\|net9 \3\:I0\|net9) resistor r=1.9484 w=9.25e-08 c=0
    Rj11 (\10\:I0\|net10 \6\:I0\|net10) resistor r=2.9544 w=8.5e-08 c=0
    Rj12 (\8\:I1\|net9 \3\:I1\|net9) resistor r=1.9484 w=9.25e-08 c=0
    Rj13 (\10\:I1\|net10 \6\:I1\|net10) resistor r=2.9544 w=8.5e-08 c=0
    Rj14 (\3\:I0\|net5 \8\:I0\|net5) resistor r=2.6488 w=8e-08 c=0
    Rj15 (\10\:I0\|net6 \6\:I0\|net6) resistor r=1.9348 w=9.9e-08 c=0
    Rj16 (\3\:I1\|net5 \8\:I1\|net5) resistor r=2.6488 w=8e-08 c=0
    Rj17 (\10\:I1\|net6 \6\:I1\|net6) resistor r=1.9348 w=9.9e-08 c=0
    Rj18 (\8\:I0\|net1 \3\:I0\|net1) resistor r=1.9484 w=9.25e-08 c=0
    Rj19 (\8\:I1\|net1 \3\:I1\|net1) resistor r=1.9484 w=9.25e-08 c=0
    Rj20 (\8\:I0\|net2 \3\:I0\|net2) resistor r=2.6673 w=9e-08 c=0
    Rj21 (\8\:I1\|net2 \3\:I1\|net2) resistor r=2.6673 w=9e-08 c=0
    Rj22 (\10\:I0\|net8 \6\:I0\|net8) resistor r=1.9394 w=9.9e-08 c=0
    Rj23 (\10\:I1\|net8 \6\:I1\|net8) resistor r=1.9394 w=9.9e-08 c=0
    Rj24 (\6\:I0\|net3 \10\:I0\|net3) resistor r=3.7067 w=8.15e-08 c=0
    Rj25 (\6\:I1\|net3 \10\:I1\|net3) resistor r=3.7067 w=8.15e-08 c=0
    Rj26 (\2\:net20 \7\:net20) resistor r=1.4592 w=8.75e-08 c=0
    Rj27 (\134\:gnd! \142\:gnd!) resistor r=1.3893 w=1e-07 c=0
    Rj28 (\142\:gnd! \143\:gnd!) resistor r=1.1707 w=9e-08 c=0
    Rj29 (\143\:gnd! \144\:gnd!) resistor r=0.9043 w=1.075e-07 c=0
    Rj30 (\144\:gnd! \145\:gnd!) resistor r=0.9113 w=1.065e-07 c=0
    Rj31 (\145\:gnd! \146\:gnd!) resistor r=0.08976 w=1e-07 c=0
    Rj32 (\146\:gnd! \25\:gnd!) resistor r=0.9973 w=1e-07 c=0
    Rj33 (\146\:gnd! \148\:gnd!) resistor r=1.0884 w=9.4e-08 c=0
    Rj34 (\148\:gnd! \149\:gnd!) resistor r=0.1562 w=1e-07 c=0
    Rj35 (\148\:gnd! \150\:gnd!) resistor r=1.7717 w=9e-08 c=0
    Rj36 (\149\:gnd! \18\:gnd!) resistor r=1.0956 w=1e-07 c=0
    Rj37 (\150\:gnd! \104\:gnd!) resistor r=1.5433 w=9.4e-08 c=0
    Rj38 (\140\:gnd! \154\:gnd!) resistor r=1.2605 w=9.5e-08 c=0
    Rj39 (\154\:gnd! \155\:gnd!) resistor r=1.1653 w=9e-08 c=0
    Rj40 (\155\:gnd! \156\:gnd!) resistor r=1.0444 w=9.25e-08 c=0
    Rj41 (\156\:gnd! \157\:gnd!) resistor r=1.0659 w=9.15e-08 c=0
    Rj42 (\157\:gnd! \158\:gnd!) resistor r=0.09042 w=9.9e-08 c=0
    Rj43 (\158\:gnd! \159\:gnd!) resistor r=1.0884 w=9.4e-08 c=0
    Rj44 (\159\:gnd! \160\:gnd!) resistor r=0.1562 w=1e-07 c=0
    Rj45 (\160\:gnd! \4\:gnd!) resistor r=1.0956 w=1e-07 c=0
    Rj46 (\154\:gnd! \116\:gnd!) resistor r=1.3844 w=1e-07 c=0
    Rj47 (\158\:gnd! \11\:gnd!) resistor r=1.0032 w=9.9e-08 c=0
    Rj48 (\159\:gnd! \164\:gnd!) resistor r=1.7717 w=9e-08 c=0
    Rj49 (\164\:gnd! \90\:gnd!) resistor r=1.5433 w=9.4e-08 c=0
    Rj50 (\4\:Y2 \2\:Y2) resistor r=1.4896 w=1e-07 c=0
    Rj51 (\4\:Y6 \2\:Y6) resistor r=1.5069 w=1e-07 c=0
    Rj52 (\4\:Y0 \2\:Y0) resistor r=1.5464 w=1e-07 c=0
    Rj53 (\13\:net5 \6\:net5) resistor r=3.094 w=9e-08 c=0
    Rj55 (\7\:Y7 \6\:Y7) resistor r=1.2026 w=1e-07 c=0
    Rj56 (\4\:Y4 \2\:Y4) resistor r=1.8496 w=9.4e-08 c=0
    Rj59 (\10\:S22 \9\:S22) resistor r=4.6046 w=8.5e-08 c=0
    Rj62 (\8\:net22 \4\:net22) resistor r=5.0732 w=8e-08 c=0
    Rj63 (\101\:vdd! \106\:vdd!) resistor r=1.2833 w=9e-08 c=0
    Rj64 (\106\:vdd! \107\:vdd!) resistor r=5.6474 w=8e-08 c=0
    Rj65 (\107\:vdd! \108\:vdd!) resistor r=0.1117 w=1e-07 c=0
    Rj66 (\108\:vdd! \109\:vdd!) resistor r=0.3638 w=9.25e-08 c=0
    Rj67 (\109\:vdd! \110\:vdd!) resistor r=1.6689 w=9e-08 c=0
    Rj68 (\106\:vdd! \111\:vdd!) resistor r=0.3761 w=1e-07 c=0
    Rj69 (\111\:vdd! \112\:vdd!) resistor r=1.6788 w=9e-08 c=0
    Rj70 (\112\:vdd! \113\:vdd!) resistor r=1.046 w=9.15e-08 c=0
    Rj71 (\113\:vdd! \41\:vdd!) resistor r=1.7289 w=9.4e-08 c=0
    Rj72 (\108\:vdd! \91\:vdd!) resistor r=1.277 w=1e-07 c=0
    Rj73 (\109\:vdd! \116\:vdd!) resistor r=0.673 w=9.25e-08 c=0
    Rj74 (\110\:vdd! \117\:vdd!) resistor r=1.06 w=9.15e-08 c=0
    Rj75 (\117\:vdd! \31\:vdd!) resistor r=1.7276 w=9.4e-08 c=0
    Rj76 (\111\:vdd! vdd!) resistor r=0.5154 w=9.25e-08 c=0
    Rj77 (vdd! \119\:vdd!) resistor r=0.1577 w=9.9e-08 c=0
    Rj78 (\116\:vdd! \120\:vdd!) resistor r=1.0529 w=9.25e-08 c=0
    Rj79 (\119\:vdd! \121\:vdd!) resistor r=1.0529 w=9.25e-08 c=0
    Rj80 (\120\:vdd! \122\:vdd!) resistor r=1.0452 w=9.25e-08 c=0
    Rj81 (\121\:vdd! \123\:vdd!) resistor r=1.0484 w=9.25e-08 c=0
    Rj82 (\122\:vdd! \21\:vdd!) resistor r=0.2426 w=1e-07 c=0
    Rj83 (\123\:vdd! \125\:vdd!) resistor r=0.4773 w=1e-07 c=0
    Rj84 (\21\:vdd! \4\:vdd!) resistor r=0.7253 w=1e-07 c=0
    Rj85 (\125\:vdd! \19\:vdd!) resistor r=1.9282 w=1e-07 c=0
    Rj86 (\4\:net7 \7\:net7) resistor r=6.6925 w=8e-08 c=0
    Rj87 (\12\:net5 \10\:net5) resistor r=4.2947 w=9e-08 c=0
    Rj141 (\130\:gnd! \142\:gnd!) resistor r=0.5 w=4.9e-09 c=0
    Rj142 (\111\:gnd! \143\:gnd!) resistor r=0.5 w=4.9e-09 c=0
    Rj143 (\83\:gnd! \144\:gnd!) resistor r=0.5 w=4.9e-09 c=0
    Rj144 (\55\:gnd! \145\:gnd!) resistor r=0.5 w=4.9e-09 c=0
    Rj146 (\48\:gnd! \149\:gnd!) resistor r=0.5 w=4.9e-09 c=0
    Rj147 (\76\:gnd! \150\:gnd!) resistor r=0.5 w=4.9e-09 c=0
    Rj151 (\123\:gnd! \154\:gnd!) resistor r=0.5 w=4.9e-09 c=0
    Rj152 (\97\:gnd! \155\:gnd!) resistor r=0.5 w=4.9e-09 c=0
    Rj153 (\69\:gnd! \156\:gnd!) resistor r=0.5 w=4.9e-09 c=0
    Rj154 (\41\:gnd! \157\:gnd!) resistor r=0.5 w=4.9e-09 c=0
    Rj155 (\34\:gnd! \160\:gnd!) resistor r=0.5 w=4.9e-09 c=0
    Rj159 (\62\:gnd! \164\:gnd!) resistor r=0.5 w=4.9e-09 c=0
    Rj188 (\96\:vdd! \106\:vdd!) resistor r=0.5 w=4.9e-09 c=0
    Rj189 (\86\:vdd! \107\:vdd!) resistor r=0.5 w=4.9e-09 c=0
    Rj190 (\71\:vdd! \110\:vdd!) resistor r=0.5 w=4.9e-09 c=0
    Rj191 (\81\:vdd! \112\:vdd!) resistor r=0.5 w=4.9e-09 c=0
    Rj192 (\61\:vdd! \113\:vdd!) resistor r=0.5 w=4.9e-09 c=0
    Rj195 (\66\:vdd! \116\:vdd!) resistor r=0.5 w=4.9e-09 c=0
    Rj196 (\51\:vdd! \117\:vdd!) resistor r=0.5 w=4.9e-09 c=0
    Rj198 (\76\:vdd! \119\:vdd!) resistor r=0.5 w=4.9e-09 c=0
    Rj199 (\46\:vdd! \120\:vdd!) resistor r=0.5 w=4.9e-09 c=0
    Rj200 (\56\:vdd! \121\:vdd!) resistor r=0.5 w=4.9e-09 c=0
    Rj201 (\26\:vdd! \122\:vdd!) resistor r=0.5 w=4.9e-09 c=0
    Rj202 (\36\:vdd! \123\:vdd!) resistor r=0.5 w=4.9e-09 c=0
    Rj204 (\14\:vdd! \125\:vdd!) resistor r=0.5 w=4.9e-09 c=0
    Rk1 (X0 \1\:X0) resistor r=0.04263 w=2e-07 c=0
    Rk2 (X6 \1\:X6) resistor r=0.1257 w=1e-07 c=0
    Rk3 (X4 \1\:X4) resistor r=0.1006 w=1e-07 c=0
    Rk4 (X2 \1\:X2) resistor r=0.04105 w=2e-07 c=0
    Rk5 (\1\:X1 \3\:X1) resistor r=25.6427 w=8e-08 c=0
    Rk6 (\3\:X1 X1) resistor r=0.6647 w=8e-08 c=0
    Rk7 (\2\:X1 \3\:X1) resistor r=62 w=8e-08 c=0
    Rk8 (\1\:X3 \3\:X3) resistor r=25.6427 w=8e-08 c=0
    Rk9 (\3\:X3 X3) resistor r=0.664 w=8e-08 c=0
    Rk10 (\2\:X3 \3\:X3) resistor r=62 w=8e-08 c=0
    Rk11 (\1\:X5 \3\:X5) resistor r=25.6427 w=8e-08 c=0
    Rk12 (\3\:X5 X5) resistor r=0.7844 w=7.25e-08 c=0
    Rk13 (\2\:X5 \3\:X5) resistor r=62 w=8e-08 c=0
    Rk14 (\1\:X7 \3\:X7) resistor r=25.6427 w=8e-08 c=0
    Rk15 (\3\:X7 X7) resistor r=0.6819 w=7e-08 c=0
    Rk16 (\2\:X7 \3\:X7) resistor r=62 w=8e-08 c=0
    Rk17 (net3 \3\:net3) resistor r=25.6294 w=8e-08 c=0
    Rk18 (\3\:net3 \4\:net3) resistor r=0.07408 w=8e-08 c=0
    Rk19 (\2\:net3 \3\:net3) resistor r=62 w=8e-08 c=0
    Rk20 (net1 \2\:net1) resistor r=25.6 w=8e-08 c=0
    Rk21 (\2\:net1 \3\:net1) resistor r=62.003 w=8e-08 c=0
    Rk22 (\2\:X0 \4\:X0) resistor r=62.7173 w=6e-08 c=0
    Rk23 (\4\:X0 \5\:X0) resistor r=0.9421 w=6e-08 c=0
    Rk24 (\5\:X0 \6\:X0) resistor r=25.2054 w=7e-08 c=0
    Rk25 (\3\:X0 \4\:X0) resistor r=25 w=6e-08 c=0
    Rk26 (\2\:X2 \4\:X2) resistor r=62.7173 w=6e-08 c=0
    Rk27 (\4\:X2 \5\:X2) resistor r=1.001 w=6e-08 c=0
    Rk28 (\5\:X2 \7\:X2) resistor r=0.1403 w=7.5e-08 c=0
    Rk30 (\3\:X2 \4\:X2) resistor r=25 w=6e-08 c=0
    Rk31 (\6\:X2 \7\:X2) resistor r=25 w=7e-08 c=0
    Rk32 (\2\:X4 \4\:X4) resistor r=62.7173 w=6e-08 c=0
    Rk33 (\4\:X4 \5\:X4) resistor r=0.9421 w=6e-08 c=0
    Rk34 (\5\:X4 \6\:X4) resistor r=25.2054 w=7e-08 c=0
    Rk35 (\3\:X4 \4\:X4) resistor r=25 w=6e-08 c=0
    Rk36 (\2\:X6 \4\:X6) resistor r=62.7173 w=6e-08 c=0
    Rk37 (\4\:X6 \5\:X6) resistor r=0.9421 w=6e-08 c=0
    Rk38 (\5\:X6 \6\:X6) resistor r=25.2054 w=7e-08 c=0
    Rk39 (\3\:X6 \4\:X6) resistor r=25 w=6e-08 c=0
    Rk40 (net16 \2\:net16) resistor r=63.9156 w=6e-08 c=0
    Rk41 (\2\:net16 \3\:net16) resistor r=0.7064 w=8e-08 c=0
    Rk42 (\3\:net16 \4\:net16) resistor r=62.0315 w=1.865e-07 c=0
    Rk43 (\3\:net16 \5\:net16) resistor r=25.5655 w=8e-08 c=0
    Rk44 (net18 \2\:net18) resistor r=62.9703 w=6e-08 c=0
    Rk45 (\2\:net18 \3\:net18) resistor r=1.7266 w=6.75e-08 c=0
    Rk46 (\3\:net18 \4\:net18) resistor r=62.0315 w=1.865e-07 c=0
    Rk47 (\3\:net18 \5\:net18) resistor r=25.5655 w=8e-08 c=0
    Rk50 (\4\:vdd! \5\:vdd!) resistor r=20.6828 w=3.55e-07 c=0
    Rk54 (\9\:vdd! \10\:vdd!) resistor r=20.6819 w=3.55e-07 c=0
    Rk58 (\14\:vdd! \15\:vdd!) resistor r=20.6828 w=3.55e-07 c=0
    Rk62 (\19\:vdd! \20\:vdd!) resistor r=20.6819 w=3.55e-07 c=0
    Rk64 (\1\:gnd! \3\:gnd!) resistor r=37.5555 w=2.4e-07 c=0
    Rk65 (\3\:gnd! \4\:gnd!) resistor r=0.03306 w=2.4e-07 c=0
    Rk70 (\8\:gnd! \10\:gnd!) resistor r=37.5555 w=2.4e-07 c=0
    Rk71 (\10\:gnd! \11\:gnd!) resistor r=0.02645 w=2.4e-07 c=0
    Rk76 (\15\:gnd! \17\:gnd!) resistor r=37.5555 w=2.4e-07 c=0
    Rk77 (\17\:gnd! \18\:gnd!) resistor r=0.03306 w=2.4e-07 c=0
    Rk82 (\22\:gnd! \24\:gnd!) resistor r=37.5555 w=2.4e-07 c=0
    Rk83 (\24\:gnd! \25\:gnd!) resistor r=0.02645 w=2.4e-07 c=0
    Rk88 (S20 \1\:S20) resistor r=47.0478 w=7.25e-08 c=0
    Rk89 (S30 \1\:S30) resistor r=46.7611 w=8e-08 c=0
    Rk90 (S10 \1\:S10) resistor r=47.1521 w=6e-08 c=0
    Rk91 (\7\:I2\|N_S I2\|N_S) resistor r=46.0154 w=8e-08 c=0
    Rk92 (\7\:I2\|N_S \9\:I2\|N_S) resistor r=37.9209 w=8e-08 c=0
    Rk93 (\6\:I2\|N_S \7\:I2\|N_S) resistor r=20.6667 w=8e-08 c=0
    Rk94 (\7\:I3\|N_S I3\|N_S) resistor r=46.1215 w=7e-08 c=0
    Rk95 (\7\:I3\|N_S \9\:I3\|N_S) resistor r=37.8798 w=9e-08 c=0
    Rk96 (\6\:I3\|N_S \7\:I3\|N_S) resistor r=20.6667 w=9e-08 c=0
    Rk97 (\7\:I4\|N_S I4\|N_S) resistor r=46.0888 w=7.5e-08 c=0
    Rk98 (\7\:I4\|N_S \9\:I4\|N_S) resistor r=37.925 w=8e-08 c=0
    Rk99 (\6\:I4\|N_S \7\:I4\|N_S) resistor r=20.6667 w=8e-08 c=0
    Rk100 (\7\:I5\|N_S I5\|N_S) resistor r=46.0395 w=8e-08 c=0
    Rk101 (\7\:I5\|N_S \9\:I5\|N_S) resistor r=37.925 w=8e-08 c=0
    Rk102 (\6\:I5\|N_S \7\:I5\|N_S) resistor r=20.6667 w=8e-08 c=0
    Rk103 (S00 \1\:S00) resistor r=45.0413 w=1.2e-07 c=0
    Rk104 (\21\:vdd! \22\:vdd!) resistor r=1.4222 w=8e-08 c=0
    Rk105 (\6\:S21 S21) resistor r=47.3405 w=8.1e-08 c=0
    Rk106 (\6\:S31 S31) resistor r=47.187 w=7e-08 c=0
    Rk107 (\6\:S11 S11) resistor r=47.5118 w=6.75e-08 c=0
    Rk108 (S01 \6\:S01) resistor r=45.0466 w=1.2e-07 c=0
    Rk112 (\34\:gnd! \35\:gnd!) resistor r=37.5251 w=2.4e-07 c=0
    Rk118 (\41\:gnd! \42\:gnd!) resistor r=37.5251 w=2.4e-07 c=0
    Rk124 (\48\:gnd! \49\:gnd!) resistor r=37.5251 w=2.4e-07 c=0
    Rk130 (\55\:gnd! \56\:gnd!) resistor r=37.5251 w=2.4e-07 c=0
    Rk135 (\26\:vdd! \27\:vdd!) resistor r=20.6855 w=3.55e-07 c=0
    Rk139 (\31\:vdd! \32\:vdd!) resistor r=20.6855 w=3.55e-07 c=0
    Rk143 (\36\:vdd! \37\:vdd!) resistor r=20.6855 w=3.55e-07 c=0
    Rk147 (\41\:vdd! \42\:vdd!) resistor r=20.6855 w=3.55e-07 c=0
    Rk149 (\5\:I0\|N_S00 \8\:I0\|N_S00) resistor r=46.0145 w=8e-08 c=0
    Rk150 (\8\:I0\|N_S00 \9\:I0\|N_S00) resistor r=37.9209 w=8e-08 c=0
    Rk151 (\7\:I0\|N_S00 \8\:I0\|N_S00) resistor r=20.6667 w=8e-08 c=0
    Rk152 (\5\:I0\|N_S10 \8\:I0\|N_S10) resistor r=46.0012 w=8e-08 c=0
    Rk153 (\8\:I0\|N_S10 \9\:I0\|N_S10) resistor r=37.8798 w=9e-08 c=0
    Rk154 (\7\:I0\|N_S10 \8\:I0\|N_S10) resistor r=20.6667 w=8e-08 c=0
    Rk155 (\5\:I1\|N_S00 \8\:I1\|N_S00) resistor r=46.1162 w=7.25e-08 c=0
    Rk156 (\8\:I1\|N_S00 \9\:I1\|N_S00) resistor r=37.925 w=8e-08 c=0
    Rk157 (\7\:I1\|N_S00 \8\:I1\|N_S00) resistor r=20.6667 w=7.25e-08 c=0
    Rk158 (\5\:I1\|N_S10 \8\:I1\|N_S10) resistor r=46.0251 w=8e-08 c=0
    Rk159 (\8\:I1\|N_S10 \9\:I1\|N_S10) resistor r=37.925 w=8e-08 c=0
    Rk160 (\7\:I1\|N_S10 \8\:I1\|N_S10) resistor r=20.6667 w=8e-08 c=0
    Rk161 (\2\:I0\|net9 \3\:I0\|net9) resistor r=0.003002 w=1e-07 c=0
    Rk162 (\3\:I0\|net9 \4\:I0\|net9) resistor r=25.6015 w=8e-08 c=0
    Rk163 (I0\|net9 \2\:I0\|net9) resistor r=62 w=8e-08 c=0
    Rk164 (\2\:I0\|net5 \3\:I0\|net5) resistor r=0.003002 w=1e-07 c=0
    Rk165 (\3\:I0\|net5 \4\:I0\|net5) resistor r=25.6015 w=8e-08 c=0
    Rk166 (I0\|net5 \2\:I0\|net5) resistor r=62 w=8e-08 c=0
    Rk167 (\2\:I1\|net9 \3\:I1\|net9) resistor r=0.003002 w=1e-07 c=0
    Rk168 (\3\:I1\|net9 \4\:I1\|net9) resistor r=25.6015 w=8e-08 c=0
    Rk169 (I1\|net9 \2\:I1\|net9) resistor r=62 w=8e-08 c=0
    Rk170 (\2\:I1\|net5 \3\:I1\|net5) resistor r=0.003002 w=1e-07 c=0
    Rk171 (\3\:I1\|net5 \4\:I1\|net5) resistor r=25.6015 w=8e-08 c=0
    Rk172 (I1\|net5 \2\:I1\|net5) resistor r=62 w=8e-08 c=0
    Rk173 (\4\:net1 \6\:net1) resistor r=62.6427 w=8e-08 c=0
    Rk174 (\6\:net1 \7\:net1) resistor r=0.08236 w=8e-08 c=0
    Rk175 (\5\:net1 \6\:net1) resistor r=25 w=8e-08 c=0
    Rk176 (net17 \3\:net17) resistor r=25.6427 w=8e-08 c=0
    Rk177 (\3\:net17 \4\:net17) resistor r=3.3026 w=7.25e-08 c=0
    Rk178 (\4\:net17 \5\:net17) resistor r=1.7657 w=7e-08 c=0
    Rk179 (\5\:net17 \6\:net17) resistor r=62.0315 w=1.865e-07 c=0
    Rk180 (\4\:net17 \7\:net17) resistor r=62.9409 w=6e-08 c=0
    Rk181 (\5\:net17 \8\:net17) resistor r=25.5657 w=8e-08 c=0
    Rk182 (\2\:net17 \3\:net17) resistor r=62 w=8e-08 c=0
    Rk183 (net15 \3\:net15) resistor r=25.6427 w=8e-08 c=0
    Rk184 (\3\:net15 \4\:net15) resistor r=3.2634 w=8e-08 c=0
    Rk185 (\4\:net15 \5\:net15) resistor r=1.5902 w=8e-08 c=0
    Rk186 (\5\:net15 \6\:net15) resistor r=62.0315 w=1.865e-07 c=0
    Rk187 (\4\:net15 \7\:net15) resistor r=62.9832 w=6e-08 c=0
    Rk188 (\5\:net15 \8\:net15) resistor r=25.5658 w=8e-08 c=0
    Rk189 (\2\:net15 \3\:net15) resistor r=62 w=8e-08 c=0
    Rk190 (\5\:net3 \7\:net3) resistor r=25.6427 w=8e-08 c=0
    Rk191 (\7\:net3 \8\:net3) resistor r=0.1616 w=8e-08 c=0
    Rk192 (\6\:net3 \7\:net3) resistor r=62 w=8e-08 c=0
    Rk193 (net4 \3\:net4) resistor r=26.1988 w=6e-08 c=0
    Rk194 (\3\:net4 \5\:net4) resistor r=0.7184 w=7e-08 c=0
    Rk195 (\5\:net4 \7\:net4) resistor r=2.6131 w=7.75e-08 c=0
    Rk196 (\7\:net4 \8\:net4) resistor r=25.6286 w=8e-08 c=0
    Rk197 (\2\:net4 \3\:net4) resistor r=25 w=6e-08 c=0
    Rk198 (\4\:net4 \5\:net4) resistor r=62 w=7e-08 c=0
    Rk199 (\6\:net4 \7\:net4) resistor r=62 w=7.75e-08 c=0
    Rk200 (net2 \3\:net2) resistor r=26.2043 w=6e-08 c=0
    Rk201 (\3\:net2 \5\:net2) resistor r=0.7184 w=7e-08 c=0
    Rk202 (\5\:net2 \7\:net2) resistor r=2.9713 w=6e-08 c=0
    Rk203 (\7\:net2 \8\:net2) resistor r=25.6286 w=8e-08 c=0
    Rk204 (\2\:net2 \3\:net2) resistor r=25 w=6e-08 c=0
    Rk205 (\4\:net2 \5\:net2) resistor r=62 w=7e-08 c=0
    Rk206 (\6\:net2 \7\:net2) resistor r=62 w=6e-08 c=0
    Rk207 (\6\:net18 \8\:net18) resistor r=26.1988 w=6e-08 c=0
    Rk208 (\8\:net18 \9\:net18) resistor r=0.6749 w=7e-08 c=0
    Rk209 (\9\:net18 \10\:net18) resistor r=62.0025 w=1.25e-07 c=0
    Rk210 (\7\:net18 \8\:net18) resistor r=25 w=6e-08 c=0
    Rk211 (\6\:net16 \7\:net16) resistor r=25.9476 w=6e-08 c=0
    Rk212 (\7\:net16 \9\:net16) resistor r=0.2054 w=7e-08 c=0
    Rk213 (\9\:net16 \10\:net16) resistor r=62.7184 w=7e-08 c=0
    Rk214 (\8\:net16 \9\:net16) resistor r=25 w=7e-08 c=0
    Rk215 (I0\|net10 \2\:I0\|net10) resistor r=64.7844 w=6e-08 c=0
    Rk216 (\2\:I0\|net10 \4\:I0\|net10) resistor r=0.5655 w=8e-08 c=0
    Rk217 (\2\:I0\|net10 \5\:I0\|net10) resistor r=62.0318 w=1.835e-07 c=0
    Rk218 (\4\:I0\|net10 \6\:I0\|net10) resistor r=0.08236 w=8e-08 c=0
    Rk219 (\3\:I0\|net10 \4\:I0\|net10) resistor r=25 w=8e-08 c=0
    Rk220 (I0\|net6 \2\:I0\|net6) resistor r=64.5731 w=6e-08 c=0
    Rk221 (\2\:I0\|net6 \4\:I0\|net6) resistor r=0.5655 w=8e-08 c=0
    Rk222 (\2\:I0\|net6 \5\:I0\|net6) resistor r=62.0315 w=1.865e-07 c=0
    Rk223 (\4\:I0\|net6 \6\:I0\|net6) resistor r=0.08236 w=8e-08 c=0
    Rk224 (\3\:I0\|net6 \4\:I0\|net6) resistor r=25 w=8e-08 c=0
    Rk225 (I1\|net10 \2\:I1\|net10) resistor r=64.5731 w=6e-08 c=0
    Rk226 (\2\:I1\|net10 \4\:I1\|net10) resistor r=0.5655 w=8e-08 c=0
    Rk227 (\2\:I1\|net10 \5\:I1\|net10) resistor r=62.0315 w=1.865e-07 c=0
    Rk228 (\4\:I1\|net10 \6\:I1\|net10) resistor r=0.08236 w=8e-08 c=0
    Rk229 (\3\:I1\|net10 \4\:I1\|net10) resistor r=25 w=8e-08 c=0
    Rk230 (I1\|net6 \2\:I1\|net6) resistor r=64.7844 w=6e-08 c=0
    Rk231 (\2\:I1\|net6 \4\:I1\|net6) resistor r=0.5655 w=8e-08 c=0
    Rk232 (\2\:I1\|net6 \5\:I1\|net6) resistor r=62.0318 w=1.835e-07 c=0
    Rk233 (\4\:I1\|net6 \6\:I1\|net6) resistor r=0.08236 w=8e-08 c=0
    Rk234 (\3\:I1\|net6 \4\:I1\|net6) resistor r=25 w=8e-08 c=0
    Rk235 (\6\:S12 S12) resistor r=46.6716 w=7e-08 c=0
    Rk236 (\6\:S32 S32) resistor r=46.5976 w=7e-08 c=0
    Rk237 (\6\:S02 S02) resistor r=45.0226 w=2.1e-07 c=0
    Rk238 (\6\:S22 \9\:S22) resistor r=45.0768 w=1.25e-07 c=0
    Rk242 (\62\:gnd! \63\:gnd!) resistor r=37.5278 w=2.4e-07 c=0
    Rk248 (\69\:gnd! \70\:gnd!) resistor r=37.5278 w=2.4e-07 c=0
    Rk254 (\76\:gnd! \77\:gnd!) resistor r=37.5278 w=2.4e-07 c=0
    Rk260 (\83\:gnd! \84\:gnd!) resistor r=37.5278 w=2.4e-07 c=0
    Rk265 (\46\:vdd! \47\:vdd!) resistor r=20.6855 w=3.55e-07 c=0
    Rk269 (\51\:vdd! \52\:vdd!) resistor r=20.6855 w=3.55e-07 c=0
    Rk273 (\56\:vdd! \57\:vdd!) resistor r=20.6855 w=3.55e-07 c=0
    Rk277 (\61\:vdd! \62\:vdd!) resistor r=20.6855 w=3.55e-07 c=0
    Rk279 (\7\:I0\|N_S11 \8\:I0\|N_S11) resistor r=37.8798 w=9e-08 c=0
    Rk280 (\7\:I0\|N_S11 \5\:I0\|N_S11) resistor r=45.9251 w=9e-08 c=0
    Rk281 (\6\:I0\|N_S11 \7\:I0\|N_S11) resistor r=20.6667 w=1e-06 c=0
    Rk282 (\7\:I1\|N_S11 \8\:I1\|N_S11) resistor r=37.925 w=8e-08 c=0
    Rk283 (\7\:I1\|N_S11 \5\:I1\|N_S11) resistor r=45.9481 w=8e-08 c=0
    Rk284 (\6\:I1\|N_S11 \7\:I1\|N_S11) resistor r=20.6667 w=1e-06 c=0
    Rk285 (\5\:I0\|N_S01 \8\:I0\|N_S01) resistor r=45.9578 w=8e-08 c=0
    Rk286 (\8\:I0\|N_S01 \9\:I0\|N_S01) resistor r=37.925 w=8e-08 c=0
    Rk287 (\7\:I0\|N_S01 \8\:I0\|N_S01) resistor r=20.6667 w=8e-08 c=0
    Rk288 (\5\:I1\|N_S01 \8\:I1\|N_S01) resistor r=45.9354 w=8.65e-08 c=0
    Rk289 (\8\:I1\|N_S01 \9\:I1\|N_S01) resistor r=37.8798 w=9e-08 c=0
    Rk290 (\7\:I1\|N_S01 \8\:I1\|N_S01) resistor r=20.6667 w=8.65e-08 c=0
    Rk291 (\2\:I0\|net1 \3\:I0\|net1) resistor r=0.003002 w=1e-07 c=0
    Rk292 (\3\:I0\|net1 \4\:I0\|net1) resistor r=25.6015 w=8e-08 c=0
    Rk293 (I0\|net1 \2\:I0\|net1) resistor r=62 w=8e-08 c=0
    Rk294 (\2\:I0\|net2 \3\:I0\|net2) resistor r=0.003002 w=1e-07 c=0
    Rk295 (\3\:I0\|net2 \4\:I0\|net2) resistor r=25.6015 w=8e-08 c=0
    Rk296 (I0\|net2 \2\:I0\|net2) resistor r=62 w=8e-08 c=0
    Rk297 (\2\:I1\|net1 \3\:I1\|net1) resistor r=0.003002 w=1e-07 c=0
    Rk298 (\3\:I1\|net1 \4\:I1\|net1) resistor r=25.6015 w=8e-08 c=0
    Rk299 (I1\|net1 \2\:I1\|net1) resistor r=62 w=8e-08 c=0
    Rk300 (\2\:I1\|net2 \3\:I1\|net2) resistor r=0.003002 w=1e-07 c=0
    Rk301 (\3\:I1\|net2 \4\:I1\|net2) resistor r=25.6015 w=8e-08 c=0
    Rk302 (I1\|net2 \2\:I1\|net2) resistor r=62 w=8e-08 c=0
    Rk303 (\5\:I0\|net5 \7\:I0\|net5) resistor r=62.6427 w=8e-08 c=0
    Rk304 (\7\:I0\|net5 \8\:I0\|net5) resistor r=0.08236 w=8e-08 c=0
    Rk305 (\6\:I0\|net5 \7\:I0\|net5) resistor r=25 w=8e-08 c=0
    Rk306 (\7\:I0\|net6 \9\:I0\|net6) resistor r=62.6427 w=8e-08 c=0
    Rk307 (\9\:I0\|net6 \10\:I0\|net6) resistor r=0.08236 w=8e-08 c=0
    Rk308 (\8\:I0\|net6 \9\:I0\|net6) resistor r=25 w=8e-08 c=0
    Rk309 (\5\:I1\|net5 \7\:I1\|net5) resistor r=62.6427 w=8e-08 c=0
    Rk310 (\7\:I1\|net5 \8\:I1\|net5) resistor r=0.08236 w=8e-08 c=0
    Rk311 (\6\:I1\|net5 \7\:I1\|net5) resistor r=25 w=8e-08 c=0
    Rk312 (\7\:I1\|net6 \9\:I1\|net6) resistor r=62.6427 w=8e-08 c=0
    Rk313 (\9\:I1\|net6 \10\:I1\|net6) resistor r=0.08236 w=8e-08 c=0
    Rk314 (\8\:I1\|net6 \9\:I1\|net6) resistor r=25 w=8e-08 c=0
    Rk315 (\5\:I0\|net9 \7\:I0\|net9) resistor r=26.2043 w=6e-08 c=0
    Rk316 (\7\:I0\|net9 \8\:I0\|net9) resistor r=0.6896 w=7e-08 c=0
    Rk317 (\8\:I0\|net9 \9\:I0\|net9) resistor r=62.0039 w=1.5e-07 c=0
    Rk318 (\6\:I0\|net9 \7\:I0\|net9) resistor r=25 w=6e-08 c=0
    Rk319 (\7\:I0\|net10 \9\:I0\|net10) resistor r=26.2043 w=6e-08 c=0
    Rk320 (\9\:I0\|net10 \10\:I0\|net10) resistor r=0.6896 w=7e-08 c=0
    Rk321 (\10\:I0\|net10 \11\:I0\|net10) resistor r=62.0039 w=1.5e-07 c=0
    Rk322 (\8\:I0\|net10 \9\:I0\|net10) resistor r=25 w=6e-08 c=0
    Rk323 (\5\:I1\|net9 \7\:I1\|net9) resistor r=26.2043 w=6e-08 c=0
    Rk324 (\7\:I1\|net9 \8\:I1\|net9) resistor r=0.6896 w=7e-08 c=0
    Rk325 (\8\:I1\|net9 \9\:I1\|net9) resistor r=62.0039 w=1.5e-07 c=0
    Rk326 (\6\:I1\|net9 \7\:I1\|net9) resistor r=25 w=6e-08 c=0
    Rk327 (\7\:I1\|net10 \9\:I1\|net10) resistor r=26.2043 w=6e-08 c=0
    Rk328 (\9\:I1\|net10 \10\:I1\|net10) resistor r=0.6896 w=7e-08 c=0
    Rk329 (\10\:I1\|net10 \11\:I1\|net10) resistor r=62.0039 w=1.5e-07 c=0
    Rk330 (\8\:I1\|net10 \9\:I1\|net10) resistor r=25 w=6e-08 c=0
    Rk331 (I0\|net3 \2\:I0\|net3) resistor r=64.7844 w=6e-08 c=0
    Rk332 (\2\:I0\|net3 \4\:I0\|net3) resistor r=0.5655 w=8e-08 c=0
    Rk333 (\2\:I0\|net3 \5\:I0\|net3) resistor r=62.0318 w=1.835e-07 c=0
    Rk334 (\4\:I0\|net3 \6\:I0\|net3) resistor r=0.08236 w=8e-08 c=0
    Rk335 (\3\:I0\|net3 \4\:I0\|net3) resistor r=25 w=8e-08 c=0
    Rk336 (I0\|net8 \2\:I0\|net8) resistor r=64.5731 w=6e-08 c=0
    Rk337 (\2\:I0\|net8 \4\:I0\|net8) resistor r=0.5655 w=8e-08 c=0
    Rk338 (\2\:I0\|net8 \5\:I0\|net8) resistor r=62.0315 w=1.865e-07 c=0
    Rk339 (\4\:I0\|net8 \6\:I0\|net8) resistor r=0.08236 w=8e-08 c=0
    Rk340 (\3\:I0\|net8 \4\:I0\|net8) resistor r=25 w=8e-08 c=0
    Rk341 (I1\|net3 \2\:I1\|net3) resistor r=64.5731 w=6e-08 c=0
    Rk342 (\2\:I1\|net3 \4\:I1\|net3) resistor r=0.5655 w=8e-08 c=0
    Rk343 (\2\:I1\|net3 \5\:I1\|net3) resistor r=62.0315 w=1.865e-07 c=0
    Rk344 (\4\:I1\|net3 \6\:I1\|net3) resistor r=0.08236 w=8e-08 c=0
    Rk345 (\3\:I1\|net3 \4\:I1\|net3) resistor r=25 w=8e-08 c=0
    Rk346 (I1\|net8 \2\:I1\|net8) resistor r=64.7511 w=6e-08 c=0
    Rk347 (\2\:I1\|net8 \4\:I1\|net8) resistor r=0.5655 w=8e-08 c=0
    Rk348 (\2\:I1\|net8 \5\:I1\|net8) resistor r=62.0317 w=1.84e-07 c=0
    Rk349 (\4\:I1\|net8 \6\:I1\|net8) resistor r=0.08236 w=8e-08 c=0
    Rk350 (\3\:I1\|net8 \4\:I1\|net8) resistor r=25 w=8e-08 c=0
    Rk351 (\6\:S33 S33) resistor r=46.5863 w=7e-08 c=0
    Rk352 (\6\:S13 S13) resistor r=46.6569 w=7e-08 c=0
    Rk353 (S03 \6\:S03) resistor r=45.0181 w=2.1e-07 c=0
    Rk357 (\90\:gnd! \91\:gnd!) resistor r=37.5278 w=2.4e-07 c=0
    Rk363 (\97\:gnd! \98\:gnd!) resistor r=37.5291 w=2.4e-07 c=0
    Rk369 (\104\:gnd! \105\:gnd!) resistor r=37.5278 w=2.4e-07 c=0
    Rk375 (\111\:gnd! \112\:gnd!) resistor r=37.5291 w=2.4e-07 c=0
    Rk380 (\66\:vdd! \67\:vdd!) resistor r=20.6855 w=3.55e-07 c=0
    Rk384 (\71\:vdd! \72\:vdd!) resistor r=20.6846 w=3.55e-07 c=0
    Rk388 (\76\:vdd! \77\:vdd!) resistor r=20.6855 w=3.55e-07 c=0
    Rk392 (\81\:vdd! \82\:vdd!) resistor r=20.6846 w=3.55e-07 c=0
    Rk394 (\5\:I0\|N_S02 \8\:I0\|N_S02) resistor r=45.9578 w=8e-08 c=0
    Rk395 (\8\:I0\|N_S02 \9\:I0\|N_S02) resistor r=37.925 w=8e-08 c=0
    Rk396 (\7\:I0\|N_S02 \8\:I0\|N_S02) resistor r=20.6667 w=8e-08 c=0
    Rk397 (\5\:I0\|N_S12 \8\:I0\|N_S12) resistor r=45.9192 w=9e-08 c=0
    Rk398 (\8\:I0\|N_S12 \9\:I0\|N_S12) resistor r=37.8798 w=9e-08 c=0
    Rk399 (\7\:I0\|N_S12 \8\:I0\|N_S12) resistor r=20.6667 w=9e-08 c=0
    Rk400 (\5\:I1\|N_S02 \8\:I1\|N_S02) resistor r=45.9324 w=9e-08 c=0
    Rk401 (\8\:I1\|N_S02 \9\:I1\|N_S02) resistor r=37.8798 w=9e-08 c=0
    Rk402 (\7\:I1\|N_S02 \8\:I1\|N_S02) resistor r=20.6667 w=9e-08 c=0
    Rk403 (\5\:I1\|N_S12 \8\:I1\|N_S12) resistor r=45.95 w=7.75e-08 c=0
    Rk404 (\8\:I1\|N_S12 \9\:I1\|N_S12) resistor r=37.9381 w=7.75e-08 c=0
    Rk405 (\7\:I1\|N_S12 \8\:I1\|N_S12) resistor r=20.6667 w=7.75e-08 c=0
    Rk406 (net20 \2\:net20) resistor r=62.4129 w=8e-08 c=0
    Rk407 (\2\:net20 \3\:net20) resistor r=25.19 w=8e-08 c=0
    Rk408 (net22 \3\:net22) resistor r=25.6286 w=8e-08 c=0
    Rk409 (\3\:net22 \4\:net22) resistor r=0.1704 w=8e-08 c=0
    Rk410 (\2\:net22 \3\:net22) resistor r=62 w=8e-08 c=0
    Rk411 (\5\:I0\|net2 \7\:I0\|net2) resistor r=62.6427 w=8e-08 c=0
    Rk412 (\7\:I0\|net2 \8\:I0\|net2) resistor r=0.08236 w=8e-08 c=0
    Rk413 (\6\:I0\|net2 \7\:I0\|net2) resistor r=25 w=8e-08 c=0
    Rk414 (\7\:I0\|net8 \9\:I0\|net8) resistor r=62.6427 w=8e-08 c=0
    Rk415 (\9\:I0\|net8 \10\:I0\|net8) resistor r=0.1079 w=8e-08 c=0
    Rk416 (\8\:I0\|net8 \9\:I0\|net8) resistor r=25 w=8e-08 c=0
    Rk417 (\5\:I1\|net2 \7\:I1\|net2) resistor r=62.6427 w=8e-08 c=0
    Rk418 (\7\:I1\|net2 \8\:I1\|net2) resistor r=0.08236 w=8e-08 c=0
    Rk419 (\6\:I1\|net2 \7\:I1\|net2) resistor r=25 w=8e-08 c=0
    Rk420 (\7\:I1\|net8 \9\:I1\|net8) resistor r=62.6427 w=8e-08 c=0
    Rk421 (\9\:I1\|net8 \10\:I1\|net8) resistor r=0.1079 w=8e-08 c=0
    Rk422 (\8\:I1\|net8 \9\:I1\|net8) resistor r=25 w=8e-08 c=0
    Rk423 (\5\:I0\|net1 \7\:I0\|net1) resistor r=26.1988 w=6e-08 c=0
    Rk424 (\7\:I0\|net1 \8\:I0\|net1) resistor r=0.6896 w=7e-08 c=0
    Rk425 (\8\:I0\|net1 \9\:I0\|net1) resistor r=62.0039 w=1.5e-07 c=0
    Rk426 (\6\:I0\|net1 \7\:I0\|net1) resistor r=25 w=6e-08 c=0
    Rk427 (\7\:I0\|net3 \9\:I0\|net3) resistor r=26.2156 w=6e-08 c=0
    Rk428 (\9\:I0\|net3 \10\:I0\|net3) resistor r=0.6896 w=7e-08 c=0
    Rk429 (\10\:I0\|net3 \11\:I0\|net3) resistor r=62.0039 w=1.5e-07 c=0
    Rk430 (\8\:I0\|net3 \9\:I0\|net3) resistor r=25 w=6e-08 c=0
    Rk431 (\5\:I1\|net1 \7\:I1\|net1) resistor r=26.1988 w=6e-08 c=0
    Rk432 (\7\:I1\|net1 \8\:I1\|net1) resistor r=0.6896 w=7e-08 c=0
    Rk433 (\8\:I1\|net1 \9\:I1\|net1) resistor r=62.0039 w=1.5e-07 c=0
    Rk434 (\6\:I1\|net1 \7\:I1\|net1) resistor r=25 w=6e-08 c=0
    Rk435 (\7\:I1\|net3 \9\:I1\|net3) resistor r=26.2126 w=6e-08 c=0
    Rk436 (\9\:I1\|net3 \10\:I1\|net3) resistor r=0.6896 w=7e-08 c=0
    Rk437 (\10\:I1\|net3 \11\:I1\|net3) resistor r=62.0039 w=1.5e-07 c=0
    Rk438 (\8\:I1\|net3 \9\:I1\|net3) resistor r=25 w=6e-08 c=0
    Rk439 (net7 \2\:net7) resistor r=25.5634 w=8e-08 c=0
    Rk440 (\2\:net7 \3\:net7) resistor r=64.5766 w=6e-08 c=0
    Rk441 (\2\:net7 \4\:net7) resistor r=0.02977 w=1.8e-07 c=0
    Rk442 (\4\:net7 \5\:net7) resistor r=62.0017 w=1.8e-07 c=0
    Rk443 (net5 \2\:net5) resistor r=64.686 w=6e-08 c=0
    Rk444 (\2\:net5 \4\:net5) resistor r=0.5655 w=8e-08 c=0
    Rk445 (\2\:net5 \5\:net5) resistor r=62.0315 w=1.865e-07 c=0
    Rk446 (\4\:net5 \6\:net5) resistor r=0.06994 w=8e-08 c=0
    Rk447 (\3\:net5 \4\:net5) resistor r=25 w=8e-08 c=0
    Rk448 (S04 \6\:S04) resistor r=45.031 w=1.2e-07 c=0
    Rk451 (\116\:gnd! \118\:gnd!) resistor r=0.03702 w=2.4e-07 c=0
    Rk452 (\118\:gnd! \119\:gnd!) resistor r=37.5555 w=2.4e-07 c=0
    Rk457 (\123\:gnd! \125\:gnd!) resistor r=0.03174 w=2.4e-07 c=0
    Rk458 (\125\:gnd! \126\:gnd!) resistor r=37.5555 w=2.4e-07 c=0
    Rk463 (\130\:gnd! \132\:gnd!) resistor r=0.03306 w=2.4e-07 c=0
    Rk464 (\132\:gnd! \133\:gnd!) resistor r=37.5555 w=2.4e-07 c=0
    Rk469 (\86\:vdd! \87\:vdd!) resistor r=20.6846 w=3.55e-07 c=0
    Rk473 (\91\:vdd! \92\:vdd!) resistor r=20.6855 w=3.55e-07 c=0
    Rk477 (\96\:vdd! \97\:vdd!) resistor r=20.6846 w=3.55e-07 c=0
    Rk481 (\101\:vdd! \102\:vdd!) resistor r=20.6846 w=3.55e-07 c=0
    Rk483 (\5\:I6\|N_S \8\:I6\|N_S) resistor r=46.0145 w=8e-08 c=0
    Rk484 (\8\:I6\|N_S \9\:I6\|N_S) resistor r=37.8798 w=9e-08 c=0
    Rk485 (\7\:I6\|N_S \8\:I6\|N_S) resistor r=20.6667 w=8e-08 c=0
    Rk486 (\5\:I7\|N_S \8\:I7\|N_S) resistor r=46.0145 w=8e-08 c=0
    Rk487 (\8\:I7\|N_S \9\:I7\|N_S) resistor r=37.8798 w=9e-08 c=0
    Rk488 (\7\:I7\|N_S \8\:I7\|N_S) resistor r=20.6667 w=8e-08 c=0
    Rk489 (\5\:I8\|N_S \8\:I8\|N_S) resistor r=46.0383 w=7.75e-08 c=0
    Rk490 (\8\:I8\|N_S \9\:I8\|N_S) resistor r=37.8798 w=9e-08 c=0
    Rk491 (\7\:I8\|N_S \8\:I8\|N_S) resistor r=20.6667 w=7.75e-08 c=0
    Rk492 (\5\:I9\|N_S \8\:I9\|N_S) resistor r=46.0908 w=7.25e-08 c=0
    Rk493 (\8\:I9\|N_S \9\:I9\|N_S) resistor r=37.9156 w=8e-08 c=0
    Rk494 (\7\:I9\|N_S \8\:I9\|N_S) resistor r=20.6667 w=7.25e-08 c=0
    Rk495 (\1\:Y0 \2\:Y0) resistor r=62.3091 w=8e-08 c=0
    Rk496 (\2\:Y0 \3\:Y0) resistor r=25.2991 w=8e-08 c=0
    Rk497 (\1\:Y2 \2\:Y2) resistor r=62.3091 w=8e-08 c=0
    Rk498 (\2\:Y2 \3\:Y2) resistor r=25.2991 w=8e-08 c=0
    Rk499 (\1\:Y4 \2\:Y4) resistor r=62.3091 w=8e-08 c=0
    Rk500 (\2\:Y4 \3\:Y4) resistor r=25.2991 w=8e-08 c=0
    Rk501 (\1\:Y6 \2\:Y6) resistor r=62.4295 w=8e-08 c=0
    Rk502 (\2\:Y6 \3\:Y6) resistor r=25.1734 w=8e-08 c=0
    Rk503 (net21 \3\:net21) resistor r=25.6427 w=8e-08 c=0
    Rk504 (\3\:net21 \5\:net21) resistor r=2.1597 w=6.75e-08 c=0
    Rk505 (\5\:net21 \6\:net21) resistor r=0.03146 w=1.865e-07 c=0
    Rk506 (\6\:net21 \7\:net21) resistor r=64.5766 w=6e-08 c=0
    Rk507 (\6\:net21 \8\:net21) resistor r=25.5655 w=8e-08 c=0
    Rk508 (\2\:net21 \3\:net21) resistor r=62 w=8e-08 c=0
    Rk509 (\4\:net21 \5\:net21) resistor r=62 w=6.75e-08 c=0
    Rk510 (net19 \3\:net19) resistor r=25.6427 w=8e-08 c=0
    Rk511 (\3\:net19 \5\:net19) resistor r=2.1871 w=6.25e-08 c=0
    Rk512 (\5\:net19 \6\:net19) resistor r=0.03146 w=1.865e-07 c=0
    Rk513 (\6\:net19 \7\:net19) resistor r=64.7427 w=6e-08 c=0
    Rk514 (\6\:net19 \8\:net19) resistor r=25.5655 w=8e-08 c=0
    Rk515 (\2\:net19 \3\:net19) resistor r=62 w=8e-08 c=0
    Rk516 (\4\:net19 \5\:net19) resistor r=62 w=6.25e-08 c=0
    Rk517 (net8 \3\:net8) resistor r=26.1932 w=6e-08 c=0
    Rk518 (\3\:net8 \5\:net8) resistor r=0.7184 w=7e-08 c=0
    Rk519 (\5\:net8 \7\:net8) resistor r=1.8862 w=8e-08 c=0
    Rk520 (\7\:net8 \8\:net8) resistor r=25.6286 w=8e-08 c=0
    Rk521 (\2\:net8 \3\:net8) resistor r=25 w=6e-08 c=0
    Rk522 (\4\:net8 \5\:net8) resistor r=62 w=7e-08 c=0
    Rk523 (\6\:net8 \7\:net8) resistor r=62 w=8e-08 c=0
    Rk524 (net6 \3\:net6) resistor r=26.1932 w=6e-08 c=0
    Rk525 (\3\:net6 \5\:net6) resistor r=0.7184 w=7e-08 c=0
    Rk526 (\5\:net6 \7\:net6) resistor r=2.1209 w=7e-08 c=0
    Rk527 (\7\:net6 \8\:net6) resistor r=25.6286 w=8e-08 c=0
    Rk528 (\2\:net6 \3\:net6) resistor r=25 w=6e-08 c=0
    Rk529 (\4\:net6 \5\:net6) resistor r=62 w=7e-08 c=0
    Rk530 (\6\:net6 \7\:net6) resistor r=62 w=7e-08 c=0
    Rk531 (\6\:net7 \7\:net7) resistor r=25.2054 w=7e-08 c=0
    Rk532 (\7\:net7 \9\:net7) resistor r=0.9418 w=6e-08 c=0
    Rk533 (\9\:net7 \10\:net7) resistor r=62.7184 w=7e-08 c=0
    Rk534 (\8\:net7 \9\:net7) resistor r=25 w=6e-08 c=0
    Rk535 (\7\:net5 \9\:net5) resistor r=26.1932 w=6e-08 c=0
    Rk536 (\9\:net5 \10\:net5) resistor r=0.6896 w=7e-08 c=0
    Rk537 (\10\:net5 \11\:net5) resistor r=62.0174 w=1.5e-07 c=0
    Rk538 (\8\:net5 \9\:net5) resistor r=25 w=6e-08 c=0
    Rk540 (S24 \6\:S24) resistor r=46.7269 w=6e-08 c=0
    Rk541 (\6\:S23 S23) resistor r=48.5189 w=6e-08 c=0
    Rk543 (\1\:Y3 \2\:Y3) resistor r=25.5634 w=8e-08 c=0
    Rk544 (\2\:Y3 \3\:Y3) resistor r=0.8083 w=7e-08 c=0
    Rk545 (\3\:Y3 Y3) resistor r=0.2045 w=7e-08 c=0
    Rk547 (\2\:Y3 \5\:Y3) resistor r=62.0316 w=1.85e-07 c=0
    Rk548 (\3\:Y3 \6\:Y3) resistor r=64.1175 w=6e-08 c=0
    Rk549 (\1\:Y7 \2\:Y7) resistor r=25.5634 w=8e-08 c=0
    Rk550 (\2\:Y7 \3\:Y7) resistor r=0.802 w=7e-08 c=0
    Rk551 (\3\:Y7 \4\:Y7) resistor r=63.9679 w=6e-08 c=0
    Rk552 (\2\:Y7 \5\:Y7) resistor r=62.0315 w=1.865e-07 c=0
    Rk553 (\3\:Y7 Y7) resistor r=0.2629 w=8e-08 c=0
    Rk554 (Y7 \6\:Y7) resistor r=0.02771 w=8e-08 c=0
    Rk555 (\1\:Y5 \2\:Y5) resistor r=25.5634 w=8e-08 c=0
    Rk556 (\2\:Y5 \3\:Y5) resistor r=0.7849 w=7e-08 c=0
    Rk557 (\3\:Y5 \4\:Y5) resistor r=64.08 w=6e-08 c=0
    Rk558 (\2\:Y5 \5\:Y5) resistor r=62.0315 w=1.865e-07 c=0
    Rk559 (\3\:Y5 Y5) resistor r=0.2955 w=8.5e-08 c=0
    Rk562 (S34 \6\:S34) resistor r=46.9746 w=6e-08 c=0
    Rk563 (\134\:gnd! \136\:gnd!) resistor r=0.03306 w=2.4e-07 c=0
    Rk564 (\136\:gnd! \137\:gnd!) resistor r=37.5555 w=2.4e-07 c=0
    Rk565 (\134\:gnd! \139\:gnd!) resistor r=0.03559 w=2.4e-07 c=0
    Rk566 (\139\:gnd! 0) resistor r=2.9904 w=6e-08 c=0
    Rk567 (0 \140\:gnd!) resistor r=2.4977 w=7e-08 c=0
    Rk570 (\4\:net20 \6\:net20) resistor r=25.6427 w=8e-08 c=0
    Rk571 (\6\:net20 \7\:net20) resistor r=8.8752 w=6.5e-08 c=0
    Rk572 (\5\:net20 \6\:net20) resistor r=62 w=8e-08 c=0
    Rk573 (\5\:net22 \7\:net22) resistor r=25.6427 w=8e-08 c=0
    Rk574 (\7\:net22 \8\:net22) resistor r=1.2868 w=8e-08 c=0
    Rk575 (\6\:net22 \7\:net22) resistor r=62 w=8e-08 c=0
    Rk576 (Y0 \4\:Y0) resistor r=0.8019 w=9.65e-08 c=0
    Rk577 (S14 \6\:S14) resistor r=46.7629 w=7e-08 c=0
    Rk578 (\12\:net5 \13\:net5) resistor r=0.798 w=8e-08 c=0
    Rk579 (Y1 \1\:Y1) resistor r=0.2072 w=9e-08 c=0
    Rk580 (\1\:Y1 \2\:Y1) resistor r=63.9679 w=6e-08 c=0
    Rk581 (\1\:Y1 \3\:Y1) resistor r=0.7177 w=8e-08 c=0
    Rk582 (\3\:Y1 \4\:Y1) resistor r=25.5655 w=8e-08 c=0
    Rk583 (\3\:Y1 \5\:Y1) resistor r=62.0315 w=1.865e-07 c=0
    Rk584 (S22 \10\:S22) resistor r=0.05568 w=9e-08 c=0
    Rk585 (Y4 \4\:Y4) resistor r=0.08139 w=1e-07 c=0
    Rk586 (Y6 \4\:Y6) resistor r=0.5285 w=1e-07 c=0
    Rk587 (Y7 \7\:Y7) resistor r=0.1999 w=1e-07 c=0
    Rk588 (Y2 \4\:Y2) resistor r=0.3509 w=9e-08 c=0
    Rl1 (I2\|N_S \2\:I2\|N_S) resistor r=51.1559 w=3.9e-08 c=0
    Rl2 (\2\:I2\|N_S \3\:I2\|N_S) resistor r=169.231 w=3.9e-08 c=0
    Rl3 (\3\:I2\|N_S \4\:I2\|N_S) resistor r=280.335 w=3.9e-08 c=0
    Rl4 (\4\:I2\|N_S \5\:I2\|N_S) resistor r=169.231 w=3.9e-08 c=0
    Rl5 (I3\|N_S \2\:I3\|N_S) resistor r=51.1559 w=3.9e-08 c=0
    Rl6 (\2\:I3\|N_S \3\:I3\|N_S) resistor r=169.231 w=3.9e-08 c=0
    Rl7 (\3\:I3\|N_S \4\:I3\|N_S) resistor r=280.335 w=3.9e-08 c=0
    Rl8 (\4\:I3\|N_S \5\:I3\|N_S) resistor r=169.231 w=3.9e-08 c=0
    Rl9 (I4\|N_S \2\:I4\|N_S) resistor r=51.1559 w=3.9e-08 c=0
    Rl10 (\2\:I4\|N_S \3\:I4\|N_S) resistor r=169.231 w=3.9e-08 c=0
    Rl11 (\3\:I4\|N_S \4\:I4\|N_S) resistor r=280.335 w=3.9e-08 c=0
    Rl12 (\4\:I4\|N_S \5\:I4\|N_S) resistor r=169.231 w=3.9e-08 c=0
    Rl13 (I5\|N_S \2\:I5\|N_S) resistor r=51.1559 w=3.9e-08 c=0
    Rl14 (\2\:I5\|N_S \3\:I5\|N_S) resistor r=169.231 w=3.9e-08 c=0
    Rl15 (\3\:I5\|N_S \4\:I5\|N_S) resistor r=280.335 w=3.9e-08 c=0
    Rl16 (\4\:I5\|N_S \5\:I5\|N_S) resistor r=169.231 w=3.9e-08 c=0
    Rl17 (\1\:S00 \2\:S00) resistor r=151.156 w=3.9e-08 c=0
    Rl18 (\2\:S00 \3\:S00) resistor r=92.3077 w=3.9e-08 c=0
    Rl19 (\3\:S00 \4\:S00) resistor r=834.181 w=3.9e-08 c=0
    Rl20 (\4\:S00 \5\:S00) resistor r=169.231 w=3.9e-08 c=0
    Rl21 (\5\:S00 \6\:S00) resistor r=282.258 w=3.9e-08 c=0
    Rl22 (\6\:S00 \7\:S00) resistor r=169.231 w=3.9e-08 c=0
    Rl23 (\1\:S10 \2\:S10) resistor r=151.156 w=3.9e-08 c=0
    Rl24 (\2\:S10 \3\:S10) resistor r=92.3077 w=3.9e-08 c=0
    Rl25 (\3\:S10 \4\:S10) resistor r=834.181 w=3.9e-08 c=0
    Rl26 (\4\:S10 \5\:S10) resistor r=169.231 w=3.9e-08 c=0
    Rl27 (\5\:S10 \6\:S10) resistor r=282.258 w=3.9e-08 c=0
    Rl28 (\6\:S10 \7\:S10) resistor r=169.231 w=3.9e-08 c=0
    Rl29 (\1\:S20 \2\:S20) resistor r=151.156 w=3.9e-08 c=0
    Rl30 (\2\:S20 \3\:S20) resistor r=92.3077 w=3.9e-08 c=0
    Rl31 (\3\:S20 \4\:S20) resistor r=834.181 w=3.9e-08 c=0
    Rl32 (\4\:S20 \5\:S20) resistor r=169.231 w=3.9e-08 c=0
    Rl33 (\5\:S20 \6\:S20) resistor r=282.258 w=3.9e-08 c=0
    Rl34 (\6\:S20 \7\:S20) resistor r=169.231 w=3.9e-08 c=0
    Rl35 (\1\:S30 \2\:S30) resistor r=151.156 w=3.9e-08 c=0
    Rl36 (\2\:S30 \3\:S30) resistor r=92.3077 w=3.9e-08 c=0
    Rl37 (\3\:S30 \4\:S30) resistor r=834.181 w=3.9e-08 c=0
    Rl38 (\4\:S30 \5\:S30) resistor r=169.231 w=3.9e-08 c=0
    Rl39 (\5\:S30 \6\:S30) resistor r=282.258 w=3.9e-08 c=0
    Rl40 (\6\:S30 \7\:S30) resistor r=169.231 w=3.9e-08 c=0
    Rl41 (I0\|N_S00 \2\:I0\|N_S00) resistor r=169.231 w=3.9e-08 c=0
    Rl42 (\2\:I0\|N_S00 \3\:I0\|N_S00) resistor r=280.335 w=3.9e-08 c=0
    Rl43 (\3\:I0\|N_S00 \4\:I0\|N_S00) resistor r=169.231 w=3.9e-08 c=0
    Rl44 (\4\:I0\|N_S00 \5\:I0\|N_S00) resistor r=51.1559 w=3.9e-08 c=0
    Rl45 (I0\|N_S10 \2\:I0\|N_S10) resistor r=169.231 w=3.9e-08 c=0
    Rl46 (\2\:I0\|N_S10 \3\:I0\|N_S10) resistor r=280.335 w=3.9e-08 c=0
    Rl47 (\3\:I0\|N_S10 \4\:I0\|N_S10) resistor r=169.231 w=3.9e-08 c=0
    Rl48 (\4\:I0\|N_S10 \5\:I0\|N_S10) resistor r=43.4636 w=3.9e-08 c=0
    Rl49 (I1\|N_S00 \2\:I1\|N_S00) resistor r=169.231 w=3.9e-08 c=0
    Rl50 (\2\:I1\|N_S00 \3\:I1\|N_S00) resistor r=280.335 w=3.9e-08 c=0
    Rl51 (\3\:I1\|N_S00 \4\:I1\|N_S00) resistor r=169.231 w=3.9e-08 c=0
    Rl52 (\4\:I1\|N_S00 \5\:I1\|N_S00) resistor r=51.1559 w=3.9e-08 c=0
    Rl53 (I1\|N_S10 \2\:I1\|N_S10) resistor r=169.231 w=3.9e-08 c=0
    Rl54 (\2\:I1\|N_S10 \3\:I1\|N_S10) resistor r=280.335 w=3.9e-08 c=0
    Rl55 (\3\:I1\|N_S10 \4\:I1\|N_S10) resistor r=169.231 w=3.9e-08 c=0
    Rl56 (\4\:I1\|N_S10 \5\:I1\|N_S10) resistor r=43.4636 w=3.9e-08 c=0
    Rl57 (\1\:S01 \2\:S01) resistor r=282.258 w=3.9e-08 c=0
    Rl58 (\2\:S01 \3\:S01) resistor r=169.231 w=3.9e-08 c=0
    Rl59 (\3\:S01 \4\:S01) resistor r=834.181 w=3.9e-08 c=0
    Rl60 (\4\:S01 \5\:S01) resistor r=92.3077 w=3.9e-08 c=0
    Rl61 (\5\:S01 \6\:S01) resistor r=151.156 w=3.9e-08 c=0
    Rl62 (\1\:S01 \7\:S01) resistor r=169.231 w=3.9e-08 c=0
    Rl63 (\1\:S11 \2\:S11) resistor r=282.258 w=3.9e-08 c=0
    Rl64 (\2\:S11 \3\:S11) resistor r=169.231 w=3.9e-08 c=0
    Rl65 (\3\:S11 \4\:S11) resistor r=834.181 w=3.9e-08 c=0
    Rl66 (\4\:S11 \5\:S11) resistor r=92.3077 w=3.9e-08 c=0
    Rl67 (\5\:S11 \6\:S11) resistor r=151.156 w=3.9e-08 c=0
    Rl68 (\1\:S11 \7\:S11) resistor r=169.231 w=3.9e-08 c=0
    Rl69 (\1\:S21 \2\:S21) resistor r=282.258 w=3.9e-08 c=0
    Rl70 (\2\:S21 \3\:S21) resistor r=169.231 w=3.9e-08 c=0
    Rl71 (\3\:S21 \4\:S21) resistor r=834.181 w=3.9e-08 c=0
    Rl72 (\4\:S21 \5\:S21) resistor r=92.3077 w=3.9e-08 c=0
    Rl73 (\5\:S21 \6\:S21) resistor r=151.156 w=3.9e-08 c=0
    Rl74 (\1\:S21 \7\:S21) resistor r=169.231 w=3.9e-08 c=0
    Rl75 (\1\:S31 \2\:S31) resistor r=282.258 w=3.9e-08 c=0
    Rl76 (\2\:S31 \3\:S31) resistor r=169.231 w=3.9e-08 c=0
    Rl77 (\3\:S31 \4\:S31) resistor r=834.181 w=3.9e-08 c=0
    Rl78 (\4\:S31 \5\:S31) resistor r=92.3077 w=3.9e-08 c=0
    Rl79 (\5\:S31 \6\:S31) resistor r=151.156 w=3.9e-08 c=0
    Rl80 (\1\:S31 \7\:S31) resistor r=169.231 w=3.9e-08 c=0
    Rl81 (I0\|N_S01 \2\:I0\|N_S01) resistor r=169.231 w=3.9e-08 c=0
    Rl82 (\2\:I0\|N_S01 \3\:I0\|N_S01) resistor r=280.335 w=3.9e-08 c=0
    Rl83 (\3\:I0\|N_S01 \4\:I0\|N_S01) resistor r=169.231 w=3.9e-08 c=0
    Rl84 (\4\:I0\|N_S01 \5\:I0\|N_S01) resistor r=51.1559 w=3.9e-08 c=0
    Rl85 (I0\|N_S11 \2\:I0\|N_S11) resistor r=169.231 w=3.9e-08 c=0
    Rl86 (\2\:I0\|N_S11 \3\:I0\|N_S11) resistor r=280.335 w=3.9e-08 c=0
    Rl87 (\3\:I0\|N_S11 \4\:I0\|N_S11) resistor r=169.231 w=3.9e-08 c=0
    Rl88 (\4\:I0\|N_S11 \5\:I0\|N_S11) resistor r=45.3867 w=3.9e-08 c=0
    Rl89 (I1\|N_S01 \2\:I1\|N_S01) resistor r=169.231 w=3.9e-08 c=0
    Rl90 (\2\:I1\|N_S01 \3\:I1\|N_S01) resistor r=280.335 w=3.9e-08 c=0
    Rl91 (\3\:I1\|N_S01 \4\:I1\|N_S01) resistor r=169.231 w=3.9e-08 c=0
    Rl92 (\4\:I1\|N_S01 \5\:I1\|N_S01) resistor r=51.1559 w=3.9e-08 c=0
    Rl93 (I1\|N_S11 \2\:I1\|N_S11) resistor r=169.231 w=3.9e-08 c=0
    Rl94 (\2\:I1\|N_S11 \3\:I1\|N_S11) resistor r=280.335 w=3.9e-08 c=0
    Rl95 (\3\:I1\|N_S11 \4\:I1\|N_S11) resistor r=169.231 w=3.9e-08 c=0
    Rl96 (\4\:I1\|N_S11 \5\:I1\|N_S11) resistor r=45.3867 w=3.9e-08 c=0
    Rl97 (\1\:S02 \2\:S02) resistor r=282.258 w=3.9e-08 c=0
    Rl98 (\2\:S02 \3\:S02) resistor r=169.231 w=3.9e-08 c=0
    Rl99 (\3\:S02 \4\:S02) resistor r=834.181 w=3.9e-08 c=0
    Rl100 (\4\:S02 \5\:S02) resistor r=92.3077 w=3.9e-08 c=0
    Rl101 (\5\:S02 \6\:S02) resistor r=151.156 w=3.9e-08 c=0
    Rl102 (\1\:S02 \7\:S02) resistor r=169.231 w=3.9e-08 c=0
    Rl103 (\1\:S12 \2\:S12) resistor r=282.258 w=3.9e-08 c=0
    Rl104 (\2\:S12 \3\:S12) resistor r=169.231 w=3.9e-08 c=0
    Rl105 (\3\:S12 \4\:S12) resistor r=834.181 w=3.9e-08 c=0
    Rl106 (\4\:S12 \5\:S12) resistor r=92.3077 w=3.9e-08 c=0
    Rl107 (\5\:S12 \6\:S12) resistor r=151.156 w=3.9e-08 c=0
    Rl108 (\1\:S12 \7\:S12) resistor r=169.231 w=3.9e-08 c=0
    Rl109 (\1\:S22 \2\:S22) resistor r=282.258 w=3.9e-08 c=0
    Rl110 (\2\:S22 \3\:S22) resistor r=169.231 w=3.9e-08 c=0
    Rl111 (\3\:S22 \4\:S22) resistor r=834.181 w=3.9e-08 c=0
    Rl112 (\4\:S22 \5\:S22) resistor r=92.3077 w=3.9e-08 c=0
    Rl113 (\5\:S22 \6\:S22) resistor r=151.156 w=3.9e-08 c=0
    Rl114 (\1\:S22 \7\:S22) resistor r=169.231 w=3.9e-08 c=0
    Rl115 (\1\:S32 \2\:S32) resistor r=282.258 w=3.9e-08 c=0
    Rl116 (\2\:S32 \3\:S32) resistor r=169.231 w=3.9e-08 c=0
    Rl117 (\3\:S32 \4\:S32) resistor r=834.181 w=3.9e-08 c=0
    Rl118 (\4\:S32 \5\:S32) resistor r=92.3077 w=3.9e-08 c=0
    Rl119 (\5\:S32 \6\:S32) resistor r=151.156 w=3.9e-08 c=0
    Rl120 (\1\:S32 \7\:S32) resistor r=169.231 w=3.9e-08 c=0
    Rl121 (I0\|N_S02 \2\:I0\|N_S02) resistor r=169.231 w=3.9e-08 c=0
    Rl122 (\2\:I0\|N_S02 \3\:I0\|N_S02) resistor r=280.335 w=3.9e-08 c=0
    Rl123 (\3\:I0\|N_S02 \4\:I0\|N_S02) resistor r=169.231 w=3.9e-08 c=0
    Rl124 (\4\:I0\|N_S02 \5\:I0\|N_S02) resistor r=51.1559 w=3.9e-08 c=0
    Rl125 (I0\|N_S12 \2\:I0\|N_S12) resistor r=169.231 w=3.9e-08 c=0
    Rl126 (\2\:I0\|N_S12 \3\:I0\|N_S12) resistor r=280.335 w=3.9e-08 c=0
    Rl127 (\3\:I0\|N_S12 \4\:I0\|N_S12) resistor r=169.231 w=3.9e-08 c=0
    Rl128 (\4\:I0\|N_S12 \5\:I0\|N_S12) resistor r=43.4636 w=3.9e-08 c=0
    Rl129 (I1\|N_S02 \2\:I1\|N_S02) resistor r=169.231 w=3.9e-08 c=0
    Rl130 (\2\:I1\|N_S02 \3\:I1\|N_S02) resistor r=280.335 w=3.9e-08 c=0
    Rl131 (\3\:I1\|N_S02 \4\:I1\|N_S02) resistor r=169.231 w=3.9e-08 c=0
    Rl132 (\4\:I1\|N_S02 \5\:I1\|N_S02) resistor r=51.1559 w=3.9e-08 c=0
    Rl133 (I1\|N_S12 \2\:I1\|N_S12) resistor r=169.231 w=3.9e-08 c=0
    Rl134 (\2\:I1\|N_S12 \3\:I1\|N_S12) resistor r=280.335 w=3.9e-08 c=0
    Rl135 (\3\:I1\|N_S12 \4\:I1\|N_S12) resistor r=169.231 w=3.9e-08 c=0
    Rl136 (\4\:I1\|N_S12 \5\:I1\|N_S12) resistor r=43.4636 w=3.9e-08 c=0
    Rl137 (\1\:S03 \2\:S03) resistor r=282.258 w=3.9e-08 c=0
    Rl138 (\2\:S03 \3\:S03) resistor r=169.231 w=3.9e-08 c=0
    Rl139 (\3\:S03 \4\:S03) resistor r=834.181 w=3.9e-08 c=0
    Rl140 (\4\:S03 \5\:S03) resistor r=92.3077 w=3.9e-08 c=0
    Rl141 (\5\:S03 \6\:S03) resistor r=151.156 w=3.9e-08 c=0
    Rl142 (\1\:S03 \7\:S03) resistor r=169.231 w=3.9e-08 c=0
    Rl143 (\1\:S13 \2\:S13) resistor r=282.258 w=3.9e-08 c=0
    Rl144 (\2\:S13 \3\:S13) resistor r=169.231 w=3.9e-08 c=0
    Rl145 (\3\:S13 \4\:S13) resistor r=834.181 w=3.9e-08 c=0
    Rl146 (\4\:S13 \5\:S13) resistor r=92.3077 w=3.9e-08 c=0
    Rl147 (\5\:S13 \6\:S13) resistor r=151.156 w=3.9e-08 c=0
    Rl148 (\1\:S13 \7\:S13) resistor r=169.231 w=3.9e-08 c=0
    Rl149 (\1\:S23 \2\:S23) resistor r=282.258 w=3.9e-08 c=0
    Rl150 (\2\:S23 \3\:S23) resistor r=169.231 w=3.9e-08 c=0
    Rl151 (\3\:S23 \4\:S23) resistor r=834.181 w=3.9e-08 c=0
    Rl152 (\4\:S23 \5\:S23) resistor r=92.3077 w=3.9e-08 c=0
    Rl153 (\5\:S23 \6\:S23) resistor r=151.156 w=3.9e-08 c=0
    Rl154 (\1\:S23 \7\:S23) resistor r=169.231 w=3.9e-08 c=0
    Rl155 (\1\:S33 \2\:S33) resistor r=282.258 w=3.9e-08 c=0
    Rl156 (\2\:S33 \3\:S33) resistor r=169.231 w=3.9e-08 c=0
    Rl157 (\3\:S33 \4\:S33) resistor r=834.181 w=3.9e-08 c=0
    Rl158 (\4\:S33 \5\:S33) resistor r=92.3077 w=3.9e-08 c=0
    Rl159 (\5\:S33 \6\:S33) resistor r=151.156 w=3.9e-08 c=0
    Rl160 (\1\:S33 \7\:S33) resistor r=169.231 w=3.9e-08 c=0
    Rl161 (I6\|N_S \2\:I6\|N_S) resistor r=169.231 w=3.9e-08 c=0
    Rl162 (\2\:I6\|N_S \3\:I6\|N_S) resistor r=280.335 w=3.9e-08 c=0
    Rl163 (\3\:I6\|N_S \4\:I6\|N_S) resistor r=169.231 w=3.9e-08 c=0
    Rl164 (\4\:I6\|N_S \5\:I6\|N_S) resistor r=51.1559 w=3.9e-08 c=0
    Rl165 (I7\|N_S \2\:I7\|N_S) resistor r=169.231 w=3.9e-08 c=0
    Rl166 (\2\:I7\|N_S \3\:I7\|N_S) resistor r=280.335 w=3.9e-08 c=0
    Rl167 (\3\:I7\|N_S \4\:I7\|N_S) resistor r=169.231 w=3.9e-08 c=0
    Rl168 (\4\:I7\|N_S \5\:I7\|N_S) resistor r=51.1559 w=3.9e-08 c=0
    Rl169 (I8\|N_S \2\:I8\|N_S) resistor r=169.231 w=3.9e-08 c=0
    Rl170 (\2\:I8\|N_S \3\:I8\|N_S) resistor r=280.335 w=3.9e-08 c=0
    Rl171 (\3\:I8\|N_S \4\:I8\|N_S) resistor r=169.231 w=3.9e-08 c=0
    Rl172 (\4\:I8\|N_S \5\:I8\|N_S) resistor r=51.1559 w=3.9e-08 c=0
    Rl173 (I9\|N_S \2\:I9\|N_S) resistor r=169.231 w=3.9e-08 c=0
    Rl174 (\2\:I9\|N_S \3\:I9\|N_S) resistor r=280.335 w=3.9e-08 c=0
    Rl175 (\3\:I9\|N_S \4\:I9\|N_S) resistor r=169.231 w=3.9e-08 c=0
    Rl176 (\4\:I9\|N_S \5\:I9\|N_S) resistor r=51.1559 w=3.9e-08 c=0
    Rl177 (\1\:S04 \2\:S04) resistor r=282.258 w=3.9e-08 c=0
    Rl178 (\2\:S04 \3\:S04) resistor r=169.231 w=3.9e-08 c=0
    Rl179 (\3\:S04 \4\:S04) resistor r=834.181 w=3.9e-08 c=0
    Rl180 (\4\:S04 \5\:S04) resistor r=92.3077 w=3.9e-08 c=0
    Rl181 (\5\:S04 \6\:S04) resistor r=151.156 w=3.9e-08 c=0
    Rl182 (\1\:S04 \7\:S04) resistor r=169.231 w=3.9e-08 c=0
    Rl183 (\1\:S14 \2\:S14) resistor r=282.258 w=3.9e-08 c=0
    Rl184 (\2\:S14 \3\:S14) resistor r=169.231 w=3.9e-08 c=0
    Rl185 (\3\:S14 \4\:S14) resistor r=834.181 w=3.9e-08 c=0
    Rl186 (\4\:S14 \5\:S14) resistor r=92.3077 w=3.9e-08 c=0
    Rl187 (\5\:S14 \6\:S14) resistor r=151.156 w=3.9e-08 c=0
    Rl188 (\1\:S14 \7\:S14) resistor r=169.231 w=3.9e-08 c=0
    Rl189 (\1\:S24 \2\:S24) resistor r=282.258 w=3.9e-08 c=0
    Rl190 (\2\:S24 \3\:S24) resistor r=169.231 w=3.9e-08 c=0
    Rl191 (\3\:S24 \4\:S24) resistor r=834.181 w=3.9e-08 c=0
    Rl192 (\4\:S24 \5\:S24) resistor r=92.3077 w=3.9e-08 c=0
    Rl193 (\5\:S24 \6\:S24) resistor r=151.156 w=3.9e-08 c=0
    Rl194 (\1\:S24 \7\:S24) resistor r=169.231 w=3.9e-08 c=0
    Rl195 (\1\:S34 \2\:S34) resistor r=282.258 w=3.9e-08 c=0
    Rl196 (\2\:S34 \3\:S34) resistor r=169.231 w=3.9e-08 c=0
    Rl197 (\3\:S34 \4\:S34) resistor r=834.181 w=3.9e-08 c=0
    Rl198 (\4\:S34 \5\:S34) resistor r=92.3077 w=3.9e-08 c=0
    Rl199 (\5\:S34 \6\:S34) resistor r=151.156 w=3.9e-08 c=0
    Rl200 (\1\:S34 \7\:S34) resistor r=169.231 w=3.9e-08 c=0
    I0\|NM0 (\2\:net4 \3\:I0\|N_S00 \4\:I0\|net9 0) g45n1svt w=(3.6e-07) \
        l=4.5e-08 nf=1 as=5.76e-14 ad=9e-14 ps=1.04e-06 pd=1.22e-06 \
        nrd=1.16667 nrs=1.16667 sa=2.5e-07 sb=7.55e-07 sd=160n sca=15.1478 \
        scb=0.0138371 scc=0.00118653 m=(1)
    I0\|NM1 (\4\:I0\|net9 \7\:S01 \5\:net3 0) g45n1svt w=(3.6e-07) \
        l=4.5e-08 nf=1 as=5.76e-14 ad=5.76e-14 ps=1.04e-06 pd=1.04e-06 \
        nrd=1.16667 nrs=1.16667 sa=4.55e-07 sb=5.5e-07 sd=160n sca=15.1478 \
        scb=0.0138371 scc=0.00118653 m=(1)
    I0\|NM3 (\5\:net3 \2\:I0\|N_S00 \3\:I0\|net10 0) g45n1svt w=(3.6e-07) \
        l=4.5e-08 nf=1 as=5.76e-14 ad=5.76e-14 ps=1.04e-06 pd=1.04e-06 \
        nrd=1.16667 nrs=1.16667 sa=6.6e-07 sb=3.45e-07 sd=160n sca=15.1478 \
        scb=0.0138371 scc=0.00118653 m=(1)
    I0\|NM2 (net4 \3\:S01 \3\:I0\|net10 0) g45n1svt w=(3.6e-07) l=4.5e-08 \
        nf=1 as=5.76e-14 ad=5.04e-14 ps=1.04e-06 pd=1e-06 nrd=1.16667 \
        nrs=1.16667 sa=8.65e-07 sb=1.4e-07 sd=160n sca=15.1478 \
        scb=0.0138371 scc=0.00118653 m=(1)
    I0\|NM7 (\6\:I0\|net9 \3\:I0\|N_S01 \4\:I0\|net1 0) g45n1svt \
        w=(3.6e-07) l=4.5e-08 nf=1 as=5.76e-14 ad=9e-14 ps=1.04e-06 \
        pd=1.22e-06 nrd=1.16667 nrs=1.16667 sa=2.5e-07 sb=7.55e-07 sd=160n \
        sca=15.1478 scb=0.0138371 scc=0.00118653 m=(1)
    I0\|NM8 (\4\:I0\|net1 \7\:S02 \6\:I0\|net5 0) g45n1svt w=(3.6e-07) \
        l=4.5e-08 nf=1 as=5.76e-14 ad=5.76e-14 ps=1.04e-06 pd=1.04e-06 \
        nrd=1.16667 nrs=1.16667 sa=4.55e-07 sb=5.5e-07 sd=160n sca=15.1478 \
        scb=0.0138371 scc=0.00118653 m=(1)
    I0\|NM9 (\6\:I0\|net5 \2\:I0\|N_S01 \3\:I0\|net3 0) g45n1svt \
        w=(3.6e-07) l=4.5e-08 nf=1 as=5.76e-14 ad=5.76e-14 ps=1.04e-06 \
        pd=1.04e-06 nrd=1.16667 nrs=1.16667 sa=6.6e-07 sb=3.45e-07 sd=160n \
        sca=15.1478 scb=0.0138371 scc=0.00118653 m=(1)
    I0\|NM5 (\5\:I0\|net9 \3\:S02 \3\:I0\|net3 0) g45n1svt w=(3.6e-07) \
        l=4.5e-08 nf=1 as=5.76e-14 ad=5.04e-14 ps=1.04e-06 pd=1e-06 \
        nrd=1.16667 nrs=1.16667 sa=8.65e-07 sb=1.4e-07 sd=160n sca=15.1478 \
        scb=0.0138371 scc=0.00118653 m=(1)
    I0\|NM12 (\6\:I0\|net1 \3\:I0\|N_S02 \8\:net8 0) g45n1svt w=(3.6e-07) \
        l=4.5e-08 nf=1 as=5.76e-14 ad=9e-14 ps=1.04e-06 pd=1.22e-06 \
        nrd=1.16667 nrs=1.16667 sa=2.5e-07 sb=7.55e-07 sd=160n sca=15.1478 \
        scb=0.0138371 scc=0.00118653 m=(1)
    I0\|NM13 (\8\:net8 \7\:S03 \6\:I0\|net2 0) g45n1svt w=(3.6e-07) \
        l=4.5e-08 nf=1 as=5.76e-14 ad=5.76e-14 ps=1.04e-06 pd=1.04e-06 \
        nrd=1.16667 nrs=1.16667 sa=4.55e-07 sb=5.5e-07 sd=160n sca=15.1478 \
        scb=0.0138371 scc=0.00118653 m=(1)
    I0\|NM14 (\6\:I0\|net2 \2\:I0\|N_S02 net7 0) g45n1svt w=(3.6e-07) \
        l=4.5e-08 nf=1 as=5.76e-14 ad=5.76e-14 ps=1.04e-06 pd=1.04e-06 \
        nrd=1.16667 nrs=1.16667 sa=6.6e-07 sb=3.45e-07 sd=160n sca=15.1478 \
        scb=0.0138371 scc=0.00118653 m=(1)
    I0\|NM10 (\5\:I0\|net1 \3\:S03 net7 0) g45n1svt w=(3.6e-07) l=4.5e-08 \
        nf=1 as=5.76e-14 ad=5.04e-14 ps=1.04e-06 pd=1e-06 nrd=1.16667 \
        nrs=1.16667 sa=8.65e-07 sb=1.4e-07 sd=160n sca=15.1478 \
        scb=0.0138371 scc=0.00118653 m=(1)
    I1\|NM0 (\7\:net18 \3\:I1\|N_S00 \4\:I1\|net9 0) g45n1svt w=(3.6e-07) \
        l=4.5e-08 nf=1 as=5.76e-14 ad=9e-14 ps=1.04e-06 pd=1.22e-06 \
        nrd=1.16667 nrs=1.16667 sa=2.5e-07 sb=7.55e-07 sd=160n sca=15.1478 \
        scb=0.0138371 scc=0.00118653 m=(1)
    I1\|NM1 (\4\:I1\|net9 \7\:S21 net17 0) g45n1svt w=(3.6e-07) l=4.5e-08 \
        nf=1 as=5.76e-14 ad=5.76e-14 ps=1.04e-06 pd=1.04e-06 nrd=1.16667 \
        nrs=1.16667 sa=4.55e-07 sb=5.5e-07 sd=160n sca=15.1478 \
        scb=0.0138371 scc=0.00118653 m=(1)
    I1\|NM3 (net17 \2\:I1\|N_S00 \3\:I1\|net10 0) g45n1svt w=(3.6e-07) \
        l=4.5e-08 nf=1 as=5.76e-14 ad=5.76e-14 ps=1.04e-06 pd=1.04e-06 \
        nrd=1.16667 nrs=1.16667 sa=6.6e-07 sb=3.45e-07 sd=160n sca=15.1478 \
        scb=0.0138371 scc=0.00118653 m=(1)
    I1\|NM2 (\6\:net18 \3\:S21 \3\:I1\|net10 0) g45n1svt w=(3.6e-07) \
        l=4.5e-08 nf=1 as=5.76e-14 ad=5.04e-14 ps=1.04e-06 pd=1e-06 \
        nrd=1.16667 nrs=1.16667 sa=8.65e-07 sb=1.4e-07 sd=160n sca=15.1478 \
        scb=0.0138371 scc=0.00118653 m=(1)
    I1\|NM7 (\6\:I1\|net9 \3\:I1\|N_S01 \4\:I1\|net1 0) g45n1svt \
        w=(3.6e-07) l=4.5e-08 nf=1 as=5.76e-14 ad=9e-14 ps=1.04e-06 \
        pd=1.22e-06 nrd=1.16667 nrs=1.16667 sa=2.5e-07 sb=7.55e-07 sd=160n \
        sca=15.1478 scb=0.0138371 scc=0.00118653 m=(1)
    I1\|NM8 (\4\:I1\|net1 \7\:S22 \6\:I1\|net5 0) g45n1svt w=(3.6e-07) \
        l=4.5e-08 nf=1 as=5.76e-14 ad=5.76e-14 ps=1.04e-06 pd=1.04e-06 \
        nrd=1.16667 nrs=1.16667 sa=4.55e-07 sb=5.5e-07 sd=160n sca=15.1478 \
        scb=0.0138371 scc=0.00118653 m=(1)
    I1\|NM9 (\6\:I1\|net5 \2\:I1\|N_S01 \3\:I1\|net3 0) g45n1svt \
        w=(3.6e-07) l=4.5e-08 nf=1 as=5.76e-14 ad=5.76e-14 ps=1.04e-06 \
        pd=1.04e-06 nrd=1.16667 nrs=1.16667 sa=6.6e-07 sb=3.45e-07 sd=160n \
        sca=15.1478 scb=0.0138371 scc=0.00118653 m=(1)
    I1\|NM5 (\5\:I1\|net9 \3\:S22 \3\:I1\|net3 0) g45n1svt w=(3.6e-07) \
        l=4.5e-08 nf=1 as=5.76e-14 ad=5.04e-14 ps=1.04e-06 pd=1e-06 \
        nrd=1.16667 nrs=1.16667 sa=8.65e-07 sb=1.4e-07 sd=160n sca=15.1478 \
        scb=0.0138371 scc=0.00118653 m=(1)
    I1\|NM12 (\6\:I1\|net1 \3\:I1\|N_S02 net22 0) g45n1svt w=(3.6e-07) \
        l=4.5e-08 nf=1 as=5.76e-14 ad=9e-14 ps=1.04e-06 pd=1.22e-06 \
        nrd=1.16667 nrs=1.16667 sa=2.5e-07 sb=7.55e-07 sd=160n sca=15.1478 \
        scb=0.0138371 scc=0.00118653 m=(1)
    I1\|NM13 (net22 \7\:S23 \6\:I1\|net2 0) g45n1svt w=(3.6e-07) l=4.5e-08 \
        nf=1 as=5.76e-14 ad=5.76e-14 ps=1.04e-06 pd=1.04e-06 nrd=1.16667 \
        nrs=1.16667 sa=4.55e-07 sb=5.5e-07 sd=160n sca=15.1478 \
        scb=0.0138371 scc=0.00118653 m=(1)
    I1\|NM14 (\6\:I1\|net2 \2\:I1\|N_S02 \8\:net21 0) g45n1svt w=(3.6e-07) \
        l=4.5e-08 nf=1 as=5.76e-14 ad=5.76e-14 ps=1.04e-06 pd=1.04e-06 \
        nrd=1.16667 nrs=1.16667 sa=6.6e-07 sb=3.45e-07 sd=160n sca=15.1478 \
        scb=0.0138371 scc=0.00118653 m=(1)
    I1\|NM10 (\5\:I1\|net1 \3\:S23 \8\:net21 0) g45n1svt w=(3.6e-07) \
        l=4.5e-08 nf=1 as=5.76e-14 ad=5.04e-14 ps=1.04e-06 pd=1e-06 \
        nrd=1.16667 nrs=1.16667 sa=8.65e-07 sb=1.4e-07 sd=160n sca=15.1478 \
        scb=0.0138371 scc=0.00118653 m=(1)
    I5\|NM6 (\8\:net15 \4\:S30 \6\:X6 0) g45n1svt w=(3.6e-07) l=4.5e-08 \
        nf=1 as=5.04e-14 ad=5.76e-14 ps=1e-06 pd=1.04e-06 nrd=1.16667 \
        nrs=1.16667 sa=1.4e-07 sb=8.65e-07 sd=160n sca=14.6684 \
        scb=0.0137193 scc=0.00118649 m=(1)
    I4\|NM6 (\8\:net17 \4\:S20 \6\:X4 0) g45n1svt w=(3.6e-07) l=4.5e-08 \
        nf=1 as=5.04e-14 ad=5.76e-14 ps=1e-06 pd=1.04e-06 nrd=1.16667 \
        nrs=1.16667 sa=1.4e-07 sb=8.65e-07 sd=160n sca=15.1478 \
        scb=0.0138371 scc=0.00118653 m=(1)
    I3\|NM6 (\5\:net16 \4\:S10 \6\:X2 0) g45n1svt w=(3.6e-07) l=4.5e-08 \
        nf=1 as=5.04e-14 ad=5.76e-14 ps=1e-06 pd=1.04e-06 nrd=1.16667 \
        nrs=1.16667 sa=1.4e-07 sb=8.65e-07 sd=160n sca=15.1478 \
        scb=0.0138371 scc=0.00118653 m=(1)
    I2\|NM6 (\5\:net18 \4\:S00 \6\:X0 0) g45n1svt w=(3.6e-07) l=4.5e-08 \
        nf=1 as=5.04e-14 ad=5.76e-14 ps=1e-06 pd=1.04e-06 nrd=1.16667 \
        nrs=1.16667 sa=1.4e-07 sb=8.65e-07 sd=160n sca=15.1478 \
        scb=0.0138371 scc=0.00118653 m=(1)
    I5\|NM5 (\8\:net15 \4\:I5\|N_S \1\:X7 0) g45n1svt w=(3.6e-07) \
        l=4.5e-08 nf=1 as=5.76e-14 ad=5.76e-14 ps=1.04e-06 pd=1.04e-06 \
        nrd=1.16667 nrs=1.16667 sa=3.45e-07 sb=6.6e-07 sd=160n sca=14.6684 \
        scb=0.0137193 scc=0.00118649 m=(1)
    I4\|NM5 (\8\:net17 \4\:I4\|N_S \1\:X5 0) g45n1svt w=(3.6e-07) \
        l=4.5e-08 nf=1 as=5.76e-14 ad=5.76e-14 ps=1.04e-06 pd=1.04e-06 \
        nrd=1.16667 nrs=1.16667 sa=3.45e-07 sb=6.6e-07 sd=160n sca=15.1478 \
        scb=0.0138371 scc=0.00118653 m=(1)
    I3\|NM5 (\5\:net16 \4\:I3\|N_S \1\:X3 0) g45n1svt w=(3.6e-07) \
        l=4.5e-08 nf=1 as=5.76e-14 ad=5.76e-14 ps=1.04e-06 pd=1.04e-06 \
        nrd=1.16667 nrs=1.16667 sa=3.45e-07 sb=6.6e-07 sd=160n sca=15.1478 \
        scb=0.0138371 scc=0.00118653 m=(1)
    I2\|NM5 (\5\:net18 \4\:I2\|N_S \1\:X1 0) g45n1svt w=(3.6e-07) \
        l=4.5e-08 nf=1 as=5.76e-14 ad=5.76e-14 ps=1.04e-06 pd=1.04e-06 \
        nrd=1.16667 nrs=1.16667 sa=3.45e-07 sb=6.6e-07 sd=160n sca=15.1478 \
        scb=0.0138371 scc=0.00118653 m=(1)
    I5\|NM7 (net1 \7\:S30 \1\:X7 0) g45n1svt w=(3.6e-07) l=4.5e-08 nf=1 \
        as=5.76e-14 ad=5.76e-14 ps=1.04e-06 pd=1.04e-06 nrd=1.16667 \
        nrs=1.16667 sa=5.5e-07 sb=4.55e-07 sd=160n sca=14.6684 \
        scb=0.0137193 scc=0.00118649 m=(1)
    I4\|NM7 (net3 \7\:S20 \1\:X5 0) g45n1svt w=(3.6e-07) l=4.5e-08 nf=1 \
        as=5.76e-14 ad=5.76e-14 ps=1.04e-06 pd=1.04e-06 nrd=1.16667 \
        nrs=1.16667 sa=5.5e-07 sb=4.55e-07 sd=160n sca=15.1478 \
        scb=0.0138371 scc=0.00118653 m=(1)
    I3\|NM7 (\8\:net2 \7\:S10 \1\:X3 0) g45n1svt w=(3.6e-07) l=4.5e-08 \
        nf=1 as=5.76e-14 ad=5.76e-14 ps=1.04e-06 pd=1.04e-06 nrd=1.16667 \
        nrs=1.16667 sa=5.5e-07 sb=4.55e-07 sd=160n sca=15.1478 \
        scb=0.0138371 scc=0.00118653 m=(1)
    I2\|NM7 (\8\:net4 \7\:S00 \1\:X1 0) g45n1svt w=(3.6e-07) l=4.5e-08 \
        nf=1 as=5.76e-14 ad=5.76e-14 ps=1.04e-06 pd=1.04e-06 nrd=1.16667 \
        nrs=1.16667 sa=5.5e-07 sb=4.55e-07 sd=160n sca=15.1478 \
        scb=0.0138371 scc=0.00118653 m=(1)
    I5\|NM0 (net1 \3\:I5\|N_S \3\:X6 0) g45n1svt w=(3.6e-07) l=4.5e-08 \
        nf=1 as=9e-14 ad=5.76e-14 ps=1.22e-06 pd=1.04e-06 nrd=1.16667 \
        nrs=1.16667 sa=7.55e-07 sb=2.5e-07 sd=160n sca=14.6684 \
        scb=0.0137193 scc=0.00118649 m=(1)
    I4\|NM0 (net3 \3\:I4\|N_S \3\:X4 0) g45n1svt w=(3.6e-07) l=4.5e-08 \
        nf=1 as=9e-14 ad=5.76e-14 ps=1.22e-06 pd=1.04e-06 nrd=1.16667 \
        nrs=1.16667 sa=7.55e-07 sb=2.5e-07 sd=160n sca=15.1478 \
        scb=0.0138371 scc=0.00118653 m=(1)
    I3\|NM0 (\8\:net2 \3\:I3\|N_S \3\:X2 0) g45n1svt w=(3.6e-07) l=4.5e-08 \
        nf=1 as=9e-14 ad=5.76e-14 ps=1.22e-06 pd=1.04e-06 nrd=1.16667 \
        nrs=1.16667 sa=7.55e-07 sb=2.5e-07 sd=160n sca=15.1478 \
        scb=0.0138371 scc=0.00118653 m=(1)
    I2\|NM0 (\8\:net4 \3\:I2\|N_S \3\:X0 0) g45n1svt w=(3.6e-07) l=4.5e-08 \
        nf=1 as=9e-14 ad=5.76e-14 ps=1.22e-06 pd=1.04e-06 nrd=1.16667 \
        nrs=1.16667 sa=7.55e-07 sb=2.5e-07 sd=160n sca=15.1478 \
        scb=0.0138371 scc=0.00118653 m=(1)
    I1\|NM18 (\8\:net16 \3\:I1\|N_S10 \4\:I1\|net5 0) g45n1svt w=(3.6e-07) \
        l=4.5e-08 nf=1 as=5.76e-14 ad=9e-14 ps=1.04e-06 pd=1.22e-06 \
        nrd=1.16667 nrs=1.16667 sa=2.5e-07 sb=7.55e-07 sd=160n sca=14.6684 \
        scb=0.0137193 scc=0.00118649 m=(1)
    I0\|NM18 (\2\:net2 \3\:I0\|N_S10 \4\:I0\|net5 0) g45n1svt w=(3.6e-07) \
        l=4.5e-08 nf=1 as=5.76e-14 ad=9e-14 ps=1.04e-06 pd=1.22e-06 \
        nrd=1.16667 nrs=1.16667 sa=2.5e-07 sb=7.55e-07 sd=160n sca=15.1478 \
        scb=0.0138371 scc=0.00118653 m=(1)
    I1\|NM19 (\4\:I1\|net5 \7\:S31 net15 0) g45n1svt w=(3.6e-07) l=4.5e-08 \
        nf=1 as=5.76e-14 ad=5.76e-14 ps=1.04e-06 pd=1.04e-06 nrd=1.16667 \
        nrs=1.16667 sa=4.55e-07 sb=5.5e-07 sd=160n sca=14.6684 \
        scb=0.0137193 scc=0.00118649 m=(1)
    I0\|NM19 (\4\:I0\|net5 \7\:S11 \5\:net1 0) g45n1svt w=(3.6e-07) \
        l=4.5e-08 nf=1 as=5.76e-14 ad=5.76e-14 ps=1.04e-06 pd=1.04e-06 \
        nrd=1.16667 nrs=1.16667 sa=4.55e-07 sb=5.5e-07 sd=160n sca=15.1478 \
        scb=0.0138371 scc=0.00118653 m=(1)
    I1\|NM21 (net15 \2\:I1\|N_S10 \3\:I1\|net6 0) g45n1svt w=(3.6e-07) \
        l=4.5e-08 nf=1 as=5.76e-14 ad=5.76e-14 ps=1.04e-06 pd=1.04e-06 \
        nrd=1.16667 nrs=1.16667 sa=6.6e-07 sb=3.45e-07 sd=160n sca=14.6684 \
        scb=0.0137193 scc=0.00118649 m=(1)
    I0\|NM21 (\5\:net1 \2\:I0\|N_S10 \3\:I0\|net6 0) g45n1svt w=(3.6e-07) \
        l=4.5e-08 nf=1 as=5.76e-14 ad=5.76e-14 ps=1.04e-06 pd=1.04e-06 \
        nrd=1.16667 nrs=1.16667 sa=6.6e-07 sb=3.45e-07 sd=160n sca=15.1478 \
        scb=0.0138371 scc=0.00118653 m=(1)
    I1\|NM16 (\6\:net16 \3\:S31 \3\:I1\|net6 0) g45n1svt w=(3.6e-07) \
        l=4.5e-08 nf=1 as=5.76e-14 ad=5.04e-14 ps=1.04e-06 pd=1e-06 \
        nrd=1.16667 nrs=1.16667 sa=8.65e-07 sb=1.4e-07 sd=160n sca=14.6684 \
        scb=0.0137193 scc=0.00118649 m=(1)
    I0\|NM16 (net2 \3\:S11 \3\:I0\|net6 0) g45n1svt w=(3.6e-07) l=4.5e-08 \
        nf=1 as=5.76e-14 ad=5.04e-14 ps=1.04e-06 pd=1e-06 nrd=1.16667 \
        nrs=1.16667 sa=8.65e-07 sb=1.4e-07 sd=160n sca=15.1478 \
        scb=0.0138371 scc=0.00118653 m=(1)
    I1\|NM23 (\8\:I1\|net10 \3\:I1\|N_S11 \4\:I1\|net2 0) g45n1svt \
        w=(3.6e-07) l=4.5e-08 nf=1 as=5.76e-14 ad=9e-14 ps=1.04e-06 \
        pd=1.22e-06 nrd=1.16667 nrs=1.16667 sa=2.5e-07 sb=7.55e-07 sd=160n \
        sca=14.6684 scb=0.0137193 scc=0.00118649 m=(1)
    I0\|NM23 (\8\:I0\|net10 \3\:I0\|N_S11 \4\:I0\|net2 0) g45n1svt \
        w=(3.6e-07) l=4.5e-08 nf=1 as=5.76e-14 ad=9e-14 ps=1.04e-06 \
        pd=1.22e-06 nrd=1.16667 nrs=1.16667 sa=2.5e-07 sb=7.55e-07 sd=160n \
        sca=15.1478 scb=0.0138371 scc=0.00118653 m=(1)
    I1\|NM24 (\4\:I1\|net2 \7\:S32 \8\:I1\|net6 0) g45n1svt w=(3.6e-07) \
        l=4.5e-08 nf=1 as=5.76e-14 ad=5.76e-14 ps=1.04e-06 pd=1.04e-06 \
        nrd=1.16667 nrs=1.16667 sa=4.55e-07 sb=5.5e-07 sd=160n sca=14.6684 \
        scb=0.0137193 scc=0.00118649 m=(1)
    I0\|NM24 (\4\:I0\|net2 \7\:S12 \8\:I0\|net6 0) g45n1svt w=(3.6e-07) \
        l=4.5e-08 nf=1 as=5.76e-14 ad=5.76e-14 ps=1.04e-06 pd=1.04e-06 \
        nrd=1.16667 nrs=1.16667 sa=4.55e-07 sb=5.5e-07 sd=160n sca=15.1478 \
        scb=0.0138371 scc=0.00118653 m=(1)
    I1\|NM25 (\8\:I1\|net6 \2\:I1\|N_S11 \3\:I1\|net8 0) g45n1svt \
        w=(3.6e-07) l=4.5e-08 nf=1 as=5.76e-14 ad=5.76e-14 ps=1.04e-06 \
        pd=1.04e-06 nrd=1.16667 nrs=1.16667 sa=6.6e-07 sb=3.45e-07 sd=160n \
        sca=14.6684 scb=0.0137193 scc=0.00118649 m=(1)
    I0\|NM25 (\8\:I0\|net6 \2\:I0\|N_S11 \3\:I0\|net8 0) g45n1svt \
        w=(3.6e-07) l=4.5e-08 nf=1 as=5.76e-14 ad=5.76e-14 ps=1.04e-06 \
        pd=1.04e-06 nrd=1.16667 nrs=1.16667 sa=6.6e-07 sb=3.45e-07 sd=160n \
        sca=15.1478 scb=0.0138371 scc=0.00118653 m=(1)
    I1\|NM15 (\7\:I1\|net10 \3\:S32 \3\:I1\|net8 0) g45n1svt w=(3.6e-07) \
        l=4.5e-08 nf=1 as=5.76e-14 ad=5.04e-14 ps=1.04e-06 pd=1e-06 \
        nrd=1.16667 nrs=1.16667 sa=8.65e-07 sb=1.4e-07 sd=160n sca=14.6684 \
        scb=0.0137193 scc=0.00118649 m=(1)
    I0\|NM15 (\7\:I0\|net10 \3\:S12 \3\:I0\|net8 0) g45n1svt w=(3.6e-07) \
        l=4.5e-08 nf=1 as=5.76e-14 ad=5.04e-14 ps=1.04e-06 pd=1e-06 \
        nrd=1.16667 nrs=1.16667 sa=8.65e-07 sb=1.4e-07 sd=160n sca=15.1478 \
        scb=0.0138371 scc=0.00118653 m=(1)
    I1\|NM27 (\8\:I1\|net3 \3\:I1\|N_S12 \3\:net20 0) g45n1svt w=(3.6e-07) \
        l=4.5e-08 nf=1 as=5.76e-14 ad=9e-14 ps=1.04e-06 pd=1.22e-06 \
        nrd=1.16667 nrs=1.16667 sa=2.5e-07 sb=7.55e-07 sd=160n sca=14.6684 \
        scb=0.0137193 scc=0.00118649 m=(1)
    I0\|NM27 (\8\:I0\|net3 \3\:I0\|N_S12 \8\:net6 0) g45n1svt w=(3.6e-07) \
        l=4.5e-08 nf=1 as=5.76e-14 ad=9e-14 ps=1.04e-06 pd=1.22e-06 \
        nrd=1.16667 nrs=1.16667 sa=2.5e-07 sb=7.55e-07 sd=160n sca=15.1478 \
        scb=0.0138371 scc=0.00118653 m=(1)
    I1\|NM28 (\3\:net20 \7\:S33 \8\:I1\|net8 0) g45n1svt w=(3.6e-07) \
        l=4.5e-08 nf=1 as=5.76e-14 ad=5.76e-14 ps=1.04e-06 pd=1.04e-06 \
        nrd=1.16667 nrs=1.16667 sa=4.55e-07 sb=5.5e-07 sd=160n sca=14.6684 \
        scb=0.0137193 scc=0.00118649 m=(1)
    I0\|NM28 (\8\:net6 \7\:S13 \8\:I0\|net8 0) g45n1svt w=(3.6e-07) \
        l=4.5e-08 nf=1 as=5.76e-14 ad=5.76e-14 ps=1.04e-06 pd=1.04e-06 \
        nrd=1.16667 nrs=1.16667 sa=4.55e-07 sb=5.5e-07 sd=160n sca=15.1478 \
        scb=0.0138371 scc=0.00118653 m=(1)
    I1\|NM29 (\8\:I1\|net8 \2\:I1\|N_S12 \8\:net19 0) g45n1svt w=(3.6e-07) \
        l=4.5e-08 nf=1 as=5.76e-14 ad=5.76e-14 ps=1.04e-06 pd=1.04e-06 \
        nrd=1.16667 nrs=1.16667 sa=6.6e-07 sb=3.45e-07 sd=160n sca=14.6684 \
        scb=0.0137193 scc=0.00118649 m=(1)
    I0\|NM29 (\8\:I0\|net8 \2\:I0\|N_S12 \3\:net5 0) g45n1svt w=(3.6e-07) \
        l=4.5e-08 nf=1 as=5.76e-14 ad=5.76e-14 ps=1.04e-06 pd=1.04e-06 \
        nrd=1.16667 nrs=1.16667 sa=6.6e-07 sb=3.45e-07 sd=160n sca=15.1478 \
        scb=0.0138371 scc=0.00118653 m=(1)
    I1\|NM20 (\7\:I1\|net3 \3\:S33 \8\:net19 0) g45n1svt w=(3.6e-07) \
        l=4.5e-08 nf=1 as=5.76e-14 ad=5.04e-14 ps=1.04e-06 pd=1e-06 \
        nrd=1.16667 nrs=1.16667 sa=8.65e-07 sb=1.4e-07 sd=160n sca=14.6684 \
        scb=0.0137193 scc=0.00118649 m=(1)
    I0\|NM20 (\7\:I0\|net3 \3\:S13 \3\:net5 0) g45n1svt w=(3.6e-07) \
        l=4.5e-08 nf=1 as=5.76e-14 ad=5.04e-14 ps=1.04e-06 pd=1e-06 \
        nrd=1.16667 nrs=1.16667 sa=8.65e-07 sb=1.4e-07 sd=160n sca=15.1478 \
        scb=0.0138371 scc=0.00118653 m=(1)
    I9\|NM0 (\3\:Y6 \3\:I9\|N_S \8\:net5 0) g45n1svt w=(3.6e-07) l=4.5e-08 \
        nf=1 as=9e-14 ad=5.76e-14 ps=1.22e-06 pd=1.04e-06 nrd=1.16667 \
        nrs=1.16667 sa=2.5e-07 sb=7.55e-07 sd=160n sca=14.6684 \
        scb=0.0137193 scc=0.00118649 m=(1)
    I8\|NM0 (\3\:Y4 \3\:I8\|N_S \8\:net7 0) g45n1svt w=(3.6e-07) l=4.5e-08 \
        nf=1 as=9e-14 ad=5.76e-14 ps=1.22e-06 pd=1.04e-06 nrd=1.16667 \
        nrs=1.16667 sa=2.5e-07 sb=7.55e-07 sd=160n sca=15.1478 \
        scb=0.0138371 scc=0.00118653 m=(1)
    I7\|NM0 (\3\:Y2 \3\:I7\|N_S \2\:net6 0) g45n1svt w=(3.6e-07) l=4.5e-08 \
        nf=1 as=9e-14 ad=5.76e-14 ps=1.22e-06 pd=1.04e-06 nrd=1.16667 \
        nrs=1.16667 sa=2.5e-07 sb=7.55e-07 sd=160n sca=15.1478 \
        scb=0.0138371 scc=0.00118653 m=(1)
    I6\|NM0 (\3\:Y0 \3\:I6\|N_S \2\:net8 0) g45n1svt w=(3.6e-07) l=4.5e-08 \
        nf=1 as=9e-14 ad=5.76e-14 ps=1.22e-06 pd=1.04e-06 nrd=1.16667 \
        nrs=1.16667 sa=2.5e-07 sb=7.55e-07 sd=160n sca=15.1478 \
        scb=0.0138371 scc=0.00118653 m=(1)
    I9\|NM7 (\3\:Y6 \7\:S34 net19 0) g45n1svt w=(3.6e-07) l=4.5e-08 nf=1 \
        as=5.76e-14 ad=5.76e-14 ps=1.04e-06 pd=1.04e-06 nrd=1.16667 \
        nrs=1.16667 sa=4.55e-07 sb=5.5e-07 sd=160n sca=14.6684 \
        scb=0.0137193 scc=0.00118649 m=(1)
    I8\|NM7 (\3\:Y4 \7\:S24 net21 0) g45n1svt w=(3.6e-07) l=4.5e-08 nf=1 \
        as=5.76e-14 ad=5.76e-14 ps=1.04e-06 pd=1.04e-06 nrd=1.16667 \
        nrs=1.16667 sa=4.55e-07 sb=5.5e-07 sd=160n sca=15.1478 \
        scb=0.0138371 scc=0.00118653 m=(1)
    I7\|NM7 (\3\:Y2 \7\:S14 \4\:net20 0) g45n1svt w=(3.6e-07) l=4.5e-08 \
        nf=1 as=5.76e-14 ad=5.76e-14 ps=1.04e-06 pd=1.04e-06 nrd=1.16667 \
        nrs=1.16667 sa=4.55e-07 sb=5.5e-07 sd=160n sca=15.1478 \
        scb=0.0138371 scc=0.00118653 m=(1)
    I6\|NM7 (\3\:Y0 \7\:S04 \5\:net22 0) g45n1svt w=(3.6e-07) l=4.5e-08 \
        nf=1 as=5.76e-14 ad=5.76e-14 ps=1.04e-06 pd=1.04e-06 nrd=1.16667 \
        nrs=1.16667 sa=4.55e-07 sb=5.5e-07 sd=160n sca=15.1478 \
        scb=0.0138371 scc=0.00118653 m=(1)
    I9\|NM5 (\1\:Y7 \2\:I9\|N_S net19 0) g45n1svt w=(3.6e-07) l=4.5e-08 \
        nf=1 as=5.76e-14 ad=5.76e-14 ps=1.04e-06 pd=1.04e-06 nrd=1.16667 \
        nrs=1.16667 sa=6.6e-07 sb=3.45e-07 sd=160n sca=14.6684 \
        scb=0.0137193 scc=0.00118649 m=(1)
    I8\|NM5 (\1\:Y5 \2\:I8\|N_S net21 0) g45n1svt w=(3.6e-07) l=4.5e-08 \
        nf=1 as=5.76e-14 ad=5.76e-14 ps=1.04e-06 pd=1.04e-06 nrd=1.16667 \
        nrs=1.16667 sa=6.6e-07 sb=3.45e-07 sd=160n sca=15.1478 \
        scb=0.0138371 scc=0.00118653 m=(1)
    I7\|NM5 (\1\:Y3 \2\:I7\|N_S \4\:net20 0) g45n1svt w=(3.6e-07) \
        l=4.5e-08 nf=1 as=5.76e-14 ad=5.76e-14 ps=1.04e-06 pd=1.04e-06 \
        nrd=1.16667 nrs=1.16667 sa=6.6e-07 sb=3.45e-07 sd=160n sca=15.1478 \
        scb=0.0138371 scc=0.00118653 m=(1)
    I6\|NM5 (\4\:Y1 \2\:I6\|N_S \5\:net22 0) g45n1svt w=(3.6e-07) \
        l=4.5e-08 nf=1 as=5.76e-14 ad=5.76e-14 ps=1.04e-06 pd=1.04e-06 \
        nrd=1.16667 nrs=1.16667 sa=6.6e-07 sb=3.45e-07 sd=160n sca=15.1478 \
        scb=0.0138371 scc=0.00118653 m=(1)
    I9\|NM6 (\1\:Y7 \3\:S34 \7\:net5 0) g45n1svt w=(3.6e-07) l=4.5e-08 \
        nf=1 as=5.04e-14 ad=5.76e-14 ps=1e-06 pd=1.04e-06 nrd=1.16667 \
        nrs=1.16667 sa=8.65e-07 sb=1.4e-07 sd=160n sca=14.6684 \
        scb=0.0137193 scc=0.00118649 m=(1)
    I8\|NM6 (\1\:Y5 \3\:S24 \6\:net7 0) g45n1svt w=(3.6e-07) l=4.5e-08 \
        nf=1 as=5.04e-14 ad=5.76e-14 ps=1e-06 pd=1.04e-06 nrd=1.16667 \
        nrs=1.16667 sa=8.65e-07 sb=1.4e-07 sd=160n sca=15.1478 \
        scb=0.0138371 scc=0.00118653 m=(1)
    I7\|NM6 (\1\:Y3 \3\:S14 net6 0) g45n1svt w=(3.6e-07) l=4.5e-08 nf=1 \
        as=5.04e-14 ad=5.76e-14 ps=1e-06 pd=1.04e-06 nrd=1.16667 \
        nrs=1.16667 sa=8.65e-07 sb=1.4e-07 sd=160n sca=15.1478 \
        scb=0.0138371 scc=0.00118653 m=(1)
    I6\|NM6 (\4\:Y1 \3\:S04 net8 0) g45n1svt w=(3.6e-07) l=4.5e-08 nf=1 \
        as=5.04e-14 ad=5.76e-14 ps=1e-06 pd=1.04e-06 nrd=1.16667 \
        nrs=1.16667 sa=8.65e-07 sb=1.4e-07 sd=160n sca=15.1478 \
        scb=0.0138371 scc=0.00118653 m=(1)
    I0\|NM4 (\9\:I0\|N_S00 \4\:S01 \35\:gnd! 0) g45n1svt w=(2.4e-07) \
        l=4.5e-08 nf=1 as=5.28e-14 ad=3.36e-14 ps=9.2e-07 pd=7.6e-07 \
        nrd=1.16667 nrs=1.16667 sa=1.4e-07 sb=2.2e-07 sd=160n sca=16.2321 \
        scb=0.0161851 scc=0.00128725 m=(1)
    I0\|NM30 (\9\:I0\|N_S01 \4\:S02 \63\:gnd! 0) g45n1svt w=(2.4e-07) \
        l=4.5e-08 nf=1 as=5.28e-14 ad=3.36e-14 ps=9.2e-07 pd=7.6e-07 \
        nrd=1.16667 nrs=1.16667 sa=1.4e-07 sb=2.2e-07 sd=160n sca=16.2321 \
        scb=0.0161851 scc=0.00128725 m=(1)
    I0\|NM31 (\9\:I0\|N_S02 \4\:S03 \91\:gnd! 0) g45n1svt w=(2.4e-07) \
        l=4.5e-08 nf=1 as=5.28e-14 ad=3.36e-14 ps=9.2e-07 pd=7.6e-07 \
        nrd=1.16667 nrs=1.16667 sa=1.4e-07 sb=2.2e-07 sd=160n sca=16.2321 \
        scb=0.0161851 scc=0.00128725 m=(1)
    I1\|NM4 (\9\:I1\|N_S00 \4\:S21 \49\:gnd! 0) g45n1svt w=(2.4e-07) \
        l=4.5e-08 nf=1 as=5.28e-14 ad=3.36e-14 ps=9.2e-07 pd=7.6e-07 \
        nrd=1.16667 nrs=1.16667 sa=1.4e-07 sb=2.2e-07 sd=160n sca=16.2321 \
        scb=0.0161851 scc=0.00128725 m=(1)
    I1\|NM30 (\9\:I1\|N_S01 \4\:S22 \77\:gnd! 0) g45n1svt w=(2.4e-07) \
        l=4.5e-08 nf=1 as=5.28e-14 ad=3.36e-14 ps=9.2e-07 pd=7.6e-07 \
        nrd=1.16667 nrs=1.16667 sa=1.4e-07 sb=2.2e-07 sd=160n sca=16.2321 \
        scb=0.0161851 scc=0.00128725 m=(1)
    I1\|NM31 (\9\:I1\|N_S02 \4\:S23 \105\:gnd! 0) g45n1svt w=(2.4e-07) \
        l=4.5e-08 nf=1 as=5.28e-14 ad=3.36e-14 ps=9.2e-07 pd=7.6e-07 \
        nrd=1.16667 nrs=1.16667 sa=1.4e-07 sb=2.2e-07 sd=160n sca=16.2321 \
        scb=0.0161851 scc=0.00128725 m=(1)
    I5\|NM1 (\9\:I5\|N_S \3\:S30 \22\:gnd! 0) g45n1svt w=(2.4e-07) \
        l=4.5e-08 nf=1 as=5.28e-14 ad=3.36e-14 ps=9.2e-07 pd=7.6e-07 \
        nrd=1.16667 nrs=1.16667 sa=2.2e-07 sb=1.4e-07 sd=160n sca=15.9478 \
        scb=0.016129 scc=0.00128725 m=(1)
    I4\|NM1 (\9\:I4\|N_S \3\:S20 \15\:gnd! 0) g45n1svt w=(2.4e-07) \
        l=4.5e-08 nf=1 as=5.28e-14 ad=3.36e-14 ps=9.2e-07 pd=7.6e-07 \
        nrd=1.16667 nrs=1.16667 sa=2.2e-07 sb=1.4e-07 sd=160n sca=16.2321 \
        scb=0.0161851 scc=0.00128725 m=(1)
    I3\|NM1 (\9\:I3\|N_S \3\:S10 \8\:gnd! 0) g45n1svt w=(2.4e-07) \
        l=4.5e-08 nf=1 as=5.28e-14 ad=3.36e-14 ps=9.2e-07 pd=7.6e-07 \
        nrd=1.16667 nrs=1.16667 sa=2.2e-07 sb=1.4e-07 sd=160n sca=16.2321 \
        scb=0.0161851 scc=0.00128725 m=(1)
    I2\|NM1 (\9\:I2\|N_S \3\:S00 \1\:gnd! 0) g45n1svt w=(2.4e-07) \
        l=4.5e-08 nf=1 as=5.28e-14 ad=3.36e-14 ps=9.2e-07 pd=7.6e-07 \
        nrd=1.16667 nrs=1.16667 sa=2.2e-07 sb=1.4e-07 sd=160n sca=16.2321 \
        scb=0.0161851 scc=0.00128725 m=(1)
    I1\|NM34 (\9\:I1\|N_S10 \4\:S31 \56\:gnd! 0) g45n1svt w=(2.4e-07) \
        l=4.5e-08 nf=1 as=5.28e-14 ad=3.36e-14 ps=9.2e-07 pd=7.6e-07 \
        nrd=1.16667 nrs=1.16667 sa=1.4e-07 sb=2.2e-07 sd=160n sca=15.9478 \
        scb=0.016129 scc=0.00128725 m=(1)
    I0\|NM34 (\9\:I0\|N_S10 \4\:S11 \42\:gnd! 0) g45n1svt w=(2.4e-07) \
        l=4.5e-08 nf=1 as=5.28e-14 ad=3.36e-14 ps=9.2e-07 pd=7.6e-07 \
        nrd=1.16667 nrs=1.16667 sa=1.4e-07 sb=2.2e-07 sd=160n sca=16.2321 \
        scb=0.0161851 scc=0.00128725 m=(1)
    I1\|NM33 (\8\:I1\|N_S11 \4\:S32 \84\:gnd! 0) g45n1svt w=(2.4e-07) \
        l=4.5e-08 nf=1 as=5.28e-14 ad=3.36e-14 ps=9.2e-07 pd=7.6e-07 \
        nrd=1.16667 nrs=1.16667 sa=1.4e-07 sb=2.2e-07 sd=160n sca=15.9478 \
        scb=0.016129 scc=0.00128725 m=(1)
    I0\|NM33 (\8\:I0\|N_S11 \4\:S12 \70\:gnd! 0) g45n1svt w=(2.4e-07) \
        l=4.5e-08 nf=1 as=5.28e-14 ad=3.36e-14 ps=9.2e-07 pd=7.6e-07 \
        nrd=1.16667 nrs=1.16667 sa=1.4e-07 sb=2.2e-07 sd=160n sca=16.2321 \
        scb=0.0161851 scc=0.00128725 m=(1)
    I1\|NM32 (\9\:I1\|N_S12 \4\:S33 \112\:gnd! 0) g45n1svt w=(2.4e-07) \
        l=4.5e-08 nf=1 as=5.28e-14 ad=3.36e-14 ps=9.2e-07 pd=7.6e-07 \
        nrd=1.16667 nrs=1.16667 sa=1.4e-07 sb=2.2e-07 sd=160n sca=15.9478 \
        scb=0.016129 scc=0.00128725 m=(1)
    I0\|NM32 (\9\:I0\|N_S12 \4\:S13 \98\:gnd! 0) g45n1svt w=(2.4e-07) \
        l=4.5e-08 nf=1 as=5.28e-14 ad=3.36e-14 ps=9.2e-07 pd=7.6e-07 \
        nrd=1.16667 nrs=1.16667 sa=1.4e-07 sb=2.2e-07 sd=160n sca=16.2321 \
        scb=0.0161851 scc=0.00128725 m=(1)
    I9\|NM1 (\9\:I9\|N_S \4\:S34 \133\:gnd! 0) g45n1svt w=(2.4e-07) \
        l=4.5e-08 nf=1 as=5.28e-14 ad=3.36e-14 ps=9.2e-07 pd=7.6e-07 \
        nrd=1.16667 nrs=1.16667 sa=1.4e-07 sb=2.2e-07 sd=160n sca=15.9478 \
        scb=0.016129 scc=0.00128725 m=(1)
    I8\|NM1 (\9\:I8\|N_S \4\:S24 \137\:gnd! 0) g45n1svt w=(2.4e-07) \
        l=4.5e-08 nf=1 as=5.28e-14 ad=3.36e-14 ps=9.2e-07 pd=7.6e-07 \
        nrd=1.16667 nrs=1.16667 sa=1.4e-07 sb=2.2e-07 sd=160n sca=16.2321 \
        scb=0.0161851 scc=0.00128725 m=(1)
    I7\|NM1 (\9\:I7\|N_S \4\:S14 \126\:gnd! 0) g45n1svt w=(2.4e-07) \
        l=4.5e-08 nf=1 as=5.28e-14 ad=3.36e-14 ps=9.2e-07 pd=7.6e-07 \
        nrd=1.16667 nrs=1.16667 sa=1.4e-07 sb=2.2e-07 sd=160n sca=16.2321 \
        scb=0.0161851 scc=0.00128725 m=(1)
    I6\|NM1 (\9\:I6\|N_S \4\:S04 \119\:gnd! 0) g45n1svt w=(2.4e-07) \
        l=4.5e-08 nf=1 as=5.28e-14 ad=3.36e-14 ps=9.2e-07 pd=7.6e-07 \
        nrd=1.16667 nrs=1.16667 sa=1.4e-07 sb=2.2e-07 sd=160n sca=16.2321 \
        scb=0.0161851 scc=0.00128725 m=(1)
    I0\|PM31 (\7\:I0\|N_S02 \5\:S03 \67\:vdd! vdd!) g45p1svt w=(3.6e-07) \
        l=4.5e-08 nf=1 as=7.56e-14 ad=5.04e-14 ps=1.14e-06 pd=1e-06 \
        nrd=1.16667 nrs=1.16667 sa=1.4e-07 sb=2.1e-07 sd=160n sca=60.9388 \
        scb=0.0402776 scc=0.00704322 m=(1)
    I0\|PM32 (\7\:I0\|N_S12 \5\:S13 \72\:vdd! vdd!) g45p1svt w=(3.6e-07) \
        l=4.5e-08 nf=1 as=7.56e-14 ad=5.04e-14 ps=1.14e-06 pd=1e-06 \
        nrd=1.16667 nrs=1.16667 sa=1.4e-07 sb=2.1e-07 sd=160n sca=60.9388 \
        scb=0.0402776 scc=0.00704322 m=(1)
    I0\|PM30 (\7\:I0\|N_S01 \5\:S02 \47\:vdd! vdd!) g45p1svt w=(3.6e-07) \
        l=4.5e-08 nf=1 as=7.56e-14 ad=5.04e-14 ps=1.14e-06 pd=1e-06 \
        nrd=1.16667 nrs=1.16667 sa=1.4e-07 sb=2.1e-07 sd=160n sca=60.9388 \
        scb=0.0402776 scc=0.00704322 m=(1)
    I0\|PM33 (\6\:I0\|N_S11 \5\:S12 \52\:vdd! vdd!) g45p1svt w=(3.6e-07) \
        l=4.5e-08 nf=1 as=7.56e-14 ad=5.04e-14 ps=1.14e-06 pd=1e-06 \
        nrd=1.16667 nrs=1.16667 sa=1.4e-07 sb=2.1e-07 sd=160n sca=60.9388 \
        scb=0.0402776 scc=0.00704322 m=(1)
    I0\|PM4 (\7\:I0\|N_S00 \5\:S01 \27\:vdd! vdd!) g45p1svt w=(3.6e-07) \
        l=4.5e-08 nf=1 as=7.56e-14 ad=5.04e-14 ps=1.14e-06 pd=1e-06 \
        nrd=1.16667 nrs=1.16667 sa=1.4e-07 sb=2.1e-07 sd=160n sca=60.9388 \
        scb=0.0402776 scc=0.00704322 m=(1)
    I0\|PM34 (\7\:I0\|N_S10 \5\:S11 \32\:vdd! vdd!) g45p1svt w=(3.6e-07) \
        l=4.5e-08 nf=1 as=7.56e-14 ad=5.04e-14 ps=1.14e-06 pd=1e-06 \
        nrd=1.16667 nrs=1.16667 sa=1.4e-07 sb=2.1e-07 sd=160n sca=60.9388 \
        scb=0.0402776 scc=0.00704322 m=(1)
    I1\|PM31 (\7\:I1\|N_S02 \5\:S23 \77\:vdd! vdd!) g45p1svt w=(3.6e-07) \
        l=4.5e-08 nf=1 as=7.56e-14 ad=5.04e-14 ps=1.14e-06 pd=1e-06 \
        nrd=1.16667 nrs=1.16667 sa=1.4e-07 sb=2.1e-07 sd=160n sca=60.9388 \
        scb=0.0402776 scc=0.00704322 m=(1)
    I1\|PM32 (\7\:I1\|N_S12 \5\:S33 \82\:vdd! vdd!) g45p1svt w=(3.6e-07) \
        l=4.5e-08 nf=1 as=7.56e-14 ad=5.04e-14 ps=1.14e-06 pd=1e-06 \
        nrd=1.16667 nrs=1.16667 sa=1.4e-07 sb=2.1e-07 sd=160n sca=60.9388 \
        scb=0.0402776 scc=0.00704322 m=(1)
    I1\|PM30 (\7\:I1\|N_S01 \5\:S22 \57\:vdd! vdd!) g45p1svt w=(3.6e-07) \
        l=4.5e-08 nf=1 as=7.56e-14 ad=5.04e-14 ps=1.14e-06 pd=1e-06 \
        nrd=1.16667 nrs=1.16667 sa=1.4e-07 sb=2.1e-07 sd=160n sca=60.9388 \
        scb=0.0402776 scc=0.00704322 m=(1)
    I1\|PM33 (\6\:I1\|N_S11 \5\:S32 \62\:vdd! vdd!) g45p1svt w=(3.6e-07) \
        l=4.5e-08 nf=1 as=7.56e-14 ad=5.04e-14 ps=1.14e-06 pd=1e-06 \
        nrd=1.16667 nrs=1.16667 sa=1.4e-07 sb=2.1e-07 sd=160n sca=60.9388 \
        scb=0.0402776 scc=0.00704322 m=(1)
    I1\|PM4 (\7\:I1\|N_S00 \5\:S21 \37\:vdd! vdd!) g45p1svt w=(3.6e-07) \
        l=4.5e-08 nf=1 as=7.56e-14 ad=5.04e-14 ps=1.14e-06 pd=1e-06 \
        nrd=1.16667 nrs=1.16667 sa=1.4e-07 sb=2.1e-07 sd=160n sca=60.9388 \
        scb=0.0402776 scc=0.00704322 m=(1)
    I1\|PM34 (\7\:I1\|N_S10 \5\:S31 \42\:vdd! vdd!) g45p1svt w=(3.6e-07) \
        l=4.5e-08 nf=1 as=7.56e-14 ad=5.04e-14 ps=1.14e-06 pd=1e-06 \
        nrd=1.16667 nrs=1.16667 sa=1.4e-07 sb=2.1e-07 sd=160n sca=60.9388 \
        scb=0.0402776 scc=0.00704322 m=(1)
    I6\|PM1 (\7\:I6\|N_S \5\:S04 \87\:vdd! vdd!) g45p1svt w=(3.6e-07) \
        l=4.5e-08 nf=1 as=7.56e-14 ad=5.04e-14 ps=1.14e-06 pd=1e-06 \
        nrd=1.16667 nrs=1.16667 sa=1.4e-07 sb=2.1e-07 sd=160n sca=60.9388 \
        scb=0.0402776 scc=0.00704322 m=(1)
    I7\|PM1 (\7\:I7\|N_S \5\:S14 \92\:vdd! vdd!) g45p1svt w=(3.6e-07) \
        l=4.5e-08 nf=1 as=7.56e-14 ad=5.04e-14 ps=1.14e-06 pd=1e-06 \
        nrd=1.16667 nrs=1.16667 sa=1.4e-07 sb=2.1e-07 sd=160n sca=60.9388 \
        scb=0.0402776 scc=0.00704322 m=(1)
    I8\|PM1 (\7\:I8\|N_S \5\:S24 \97\:vdd! vdd!) g45p1svt w=(3.6e-07) \
        l=4.5e-08 nf=1 as=7.56e-14 ad=5.04e-14 ps=1.14e-06 pd=1e-06 \
        nrd=1.16667 nrs=1.16667 sa=1.4e-07 sb=2.1e-07 sd=160n sca=60.9388 \
        scb=0.0402776 scc=0.00704322 m=(1)
    I9\|PM1 (\7\:I9\|N_S \5\:S34 \102\:vdd! vdd!) g45p1svt w=(3.6e-07) \
        l=4.5e-08 nf=1 as=7.56e-14 ad=5.04e-14 ps=1.14e-06 pd=1e-06 \
        nrd=1.16667 nrs=1.16667 sa=1.4e-07 sb=2.1e-07 sd=160n sca=60.9388 \
        scb=0.0402776 scc=0.00704322 m=(1)
    I2\|PM1 (\6\:I2\|N_S \2\:S00 \5\:vdd! vdd!) g45p1svt w=(3.6e-07) \
        l=4.5e-08 nf=1 as=7.56e-14 ad=5.04e-14 ps=1.14e-06 pd=1e-06 \
        nrd=1.16667 nrs=1.16667 sa=1.4e-07 sb=2.1e-07 sd=160n sca=60.9388 \
        scb=0.0402776 scc=0.00704322 m=(1)
    I3\|PM1 (\6\:I3\|N_S \2\:S10 \10\:vdd! vdd!) g45p1svt w=(3.6e-07) \
        l=4.5e-08 nf=1 as=7.56e-14 ad=5.04e-14 ps=1.14e-06 pd=1e-06 \
        nrd=1.16667 nrs=1.16667 sa=1.4e-07 sb=2.1e-07 sd=160n sca=60.9388 \
        scb=0.0402776 scc=0.00704322 m=(1)
    I4\|PM1 (\6\:I4\|N_S \2\:S20 \15\:vdd! vdd!) g45p1svt w=(3.6e-07) \
        l=4.5e-08 nf=1 as=7.56e-14 ad=5.04e-14 ps=1.14e-06 pd=1e-06 \
        nrd=1.16667 nrs=1.16667 sa=1.4e-07 sb=2.1e-07 sd=160n sca=60.9388 \
        scb=0.0402776 scc=0.00704322 m=(1)
    I5\|PM1 (\6\:I5\|N_S \2\:S30 \20\:vdd! vdd!) g45p1svt w=(3.6e-07) \
        l=4.5e-08 nf=1 as=7.56e-14 ad=5.04e-14 ps=1.14e-06 pd=1e-06 \
        nrd=1.16667 nrs=1.16667 sa=1.4e-07 sb=2.1e-07 sd=160n sca=60.9388 \
        scb=0.0402776 scc=0.00704322 m=(1)
ends projeto_8x8_benes_av_extracted
// End of subcircuit definition.

// Library name: projeto
// Cell name: 4_SSI_inverter
// View name: schematic
// Inherited view list: spectre schematic cmos_sch veriloga
subckt projeto_4_SSI_inverter_schematic In Out
    PM0 (Out In vdd! vdd!) g45p1svt w=(960n) l=45n nf=1 as=134.4f \
        ad=134.4f ps=2.2u pd=2.2u nrd=145.833m nrs=145.833m sa=140n \
        sb=140n sd=160n sca=73.49607 scb=0.06642 scc=0.00874 m=(1)
    NM0 (Out In 0 0) g45n1svt w=(480n) l=45n nf=1 as=67.2f ad=67.2f \
        ps=1.24u pd=1.24u nrd=291.667m nrs=291.667m sa=140n sb=140n \
        sd=160n sca=102.54472 scb=0.08351 scc=0.01219 m=(1)
ends projeto_4_SSI_inverter_schematic
// End of subcircuit definition.

// Library name: projeto
// Cell name: 1_SSI_inverter
// View name: schematic
// Inherited view list: spectre schematic cmos_sch veriloga
subckt projeto_1_SSI_inverter_schematic In Out
    PM0 (Out In vdd! vdd!) g45p1svt w=(240n) l=45n nf=1 as=33.6f ad=33.6f \
        ps=760n pd=760n nrd=583.333m nrs=583.333m sa=140n sb=140n sd=160n \
        sca=151.92744 scb=0.10471 scc=0.01874 m=(1)
    NM0 (Out In 0 0) g45n1svt w=(120n) l=45n nf=1 as=16.8f ad=16.8f \
        ps=520n pd=520n nrd=1.16667 nrs=1.16667 sa=140n sb=140n sd=160n \
        sca=226.00151 scb=0.11734 scc=0.02767 m=(1)
ends projeto_1_SSI_inverter_schematic
// End of subcircuit definition.

// Library name: projeto
// Cell name: 8x8_benes_tb
// View name: schematic
// Inherited view list: spectre schematic cmos_sch veriloga
I0 (S00 S01 S02 S03 S04 S10 S11 S12 S13 S14 S20 S21 S22 S23 S24 S30 S31 \
        S32 S33 S34 X0 X1 X2 X3 X4 X5 X6 X7 Y0 Y1 Y2 Y3 Y4 Y5 Y6 Y7) \
        projeto_8x8_benes_av_extracted

I84 (Y4 Y4_Out) projeto_4_SSI_inverter_schematic
I83 (Y7 Y7_Out) projeto_4_SSI_inverter_schematic
I82 (Y5 Y5_Out) projeto_4_SSI_inverter_schematic
I81 (Y6 Y6_Out) projeto_4_SSI_inverter_schematic
I80 (Y2 Y2_Out) projeto_4_SSI_inverter_schematic
I79 (Y3 Y3_Out) projeto_4_SSI_inverter_schematic
I78 (Y1 Y1_Out) projeto_4_SSI_inverter_schematic
I77 (Y0 Y0_Out) projeto_4_SSI_inverter_schematic

V28 (vdd! 0) vsource dc=1 type=dc

V_S34 (S34 0) vsource dc=0 type=dc
V_S33 (S33 0) vsource dc=0 type=dc
V_S32 (S32 0) vsource dc=0 type=dc
V_S31 (S31 0) vsource dc=0 type=dc
V_S30 (S30 0) vsource dc=0 type=dc
V_S24 (S24 0) vsource dc=0 type=dc
V_S23 (S23 0) vsource dc=0 type=dc
V_S22 (S22 0) vsource dc=0 type=dc
V_S21 (S21 0) vsource dc=0 type=dc
V_S20 (S20 0) vsource dc=0 type=dc
V_S14 (S14 0) vsource dc=0 type=dc
V_S13 (S13 0) vsource dc=0 type=dc
V_S12 (S12 0) vsource dc=0 type=dc
V_S11 (S11 0) vsource dc=0 type=dc
V_S10 (S10 0) vsource dc=0 type=dc
V_S04 (S04 0) vsource dc=0 type=dc
V_S03 (S03 0) vsource dc=0 type=dc
V_S02 (S02 0) vsource dc=0 type=dc
V_S01 (S01 0) vsource dc=0 type=dc
V_S00 (S00 0) vsource dc=0 type=dc

V_X7 (X7_In 0) vsource dc=1 type=dc
V_X6 (X6_In 0) vsource dc=1 type=dc
V_X5 (X5_In 0) vsource dc=1 type=dc
V_X4 (X4_In 0) vsource dc=1 type=dc
V_X3 (X3_In 0) vsource dc=1 type=dc
V_X2 (X2_In 0) vsource dc=1 type=dc
V_X1 (X1_In 0) vsource dc=1 type=dc
V_X0 (X0_In 0) vsource dc=1 type=pulse val0=0 val1=1 period=10n delay=0 rise=1p fall=1p width=5n

I76 (net7 X7) projeto_1_SSI_inverter_schematic
I75 (X7_In net7) projeto_1_SSI_inverter_schematic
I74 (net8 X6) projeto_1_SSI_inverter_schematic
I73 (X6_In net8) projeto_1_SSI_inverter_schematic
I72 (net6 X5) projeto_1_SSI_inverter_schematic
I71 (X5_In net6) projeto_1_SSI_inverter_schematic
I70 (net5 X4) projeto_1_SSI_inverter_schematic
I69 (X4_In net5) projeto_1_SSI_inverter_schematic
I68 (net4 X3) projeto_1_SSI_inverter_schematic
I67 (X3_In net4) projeto_1_SSI_inverter_schematic
I66 (net3 X2) projeto_1_SSI_inverter_schematic
I65 (X2_In net3) projeto_1_SSI_inverter_schematic
I64 (net2 X1) projeto_1_SSI_inverter_schematic
I63 (X1_In net2) projeto_1_SSI_inverter_schematic
I48 (net1 X0) projeto_1_SSI_inverter_schematic
I47 (X0_In net1) projeto_1_SSI_inverter_schematic

simulatorOptions options psfversion="1.4.0" reltol=1e-3 vabstol=1e-6 \
    iabstol=1e-12 temp=27 tnom=27 scalem=1.0 scale=1.0 gmin=1e-12 rforce=1 \
    maxnotes=5 maxwarns=5 digits=5 cols=80 pivrel=1e-3 \
    sensfile="../psf/sens.output" checklimitdest=psf

tran tran stop=30n write="spectre.ic" writefinal="spectre.fc" \
    annotate=status maxiters=5

finalTimeOP info what=oppoint where=rawfile
modelParameter info what=models where=rawfile
element info what=inst where=rawfile
outputParameter info what=output where=rawfile
designParamVals info what=parameters where=rawfile
primitives info what=primitives where=rawfile
subckts info what=subckts where=rawfile
save X7 X6 X5 X4 X3 X2 X1 X0 Y0 Y3 Y2 Y1 Y5 Y6 Y4 Y7
saveOptions options save=allpub
